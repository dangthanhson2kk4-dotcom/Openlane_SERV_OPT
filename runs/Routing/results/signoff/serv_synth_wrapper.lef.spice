* NGSPICE file created from serv_synth_wrapper.ext - technology: sky130A

* Black-box entry subcircuit for sky130_fd_sc_hd__tapvpwrvgnd_1 abstract view
.subckt sky130_fd_sc_hd__tapvpwrvgnd_1 VGND VPWR
.ends

* Black-box entry subcircuit for sky130_fd_sc_hd__fill_2 abstract view
.subckt sky130_fd_sc_hd__fill_2 VGND VNB VPB VPWR
.ends

* Black-box entry subcircuit for sky130_fd_sc_hd__decap_3 abstract view
.subckt sky130_fd_sc_hd__decap_3 VGND VNB VPB VPWR
.ends

* Black-box entry subcircuit for sky130_fd_sc_hd__decap_4 abstract view
.subckt sky130_fd_sc_hd__decap_4 VGND VNB VPB VPWR
.ends

* Black-box entry subcircuit for sky130_fd_sc_hd__fill_1 abstract view
.subckt sky130_fd_sc_hd__fill_1 VGND VNB VPB VPWR
.ends

* Black-box entry subcircuit for sky130_ef_sc_hd__decap_12 abstract view
.subckt sky130_ef_sc_hd__decap_12 VPWR VGND VPB VNB
.ends

* Black-box entry subcircuit for sky130_fd_sc_hd__mux2_1 abstract view
.subckt sky130_fd_sc_hd__mux2_1 A0 A1 S VGND VNB VPB VPWR X
.ends

* Black-box entry subcircuit for sky130_fd_sc_hd__a22o_1 abstract view
.subckt sky130_fd_sc_hd__a22o_1 A1 A2 B1 B2 VGND VNB VPB VPWR X
.ends

* Black-box entry subcircuit for sky130_fd_sc_hd__dfxtp_1 abstract view
.subckt sky130_fd_sc_hd__dfxtp_1 CLK D VGND VNB VPB VPWR Q
.ends

* Black-box entry subcircuit for sky130_fd_sc_hd__nor2_1 abstract view
.subckt sky130_fd_sc_hd__nor2_1 A B VGND VNB VPB VPWR Y
.ends

* Black-box entry subcircuit for sky130_fd_sc_hd__clkbuf_1 abstract view
.subckt sky130_fd_sc_hd__clkbuf_1 A VGND VNB VPB VPWR X
.ends

* Black-box entry subcircuit for sky130_fd_sc_hd__clkbuf_8 abstract view
.subckt sky130_fd_sc_hd__clkbuf_8 A VGND VNB VPB VPWR X
.ends

* Black-box entry subcircuit for sky130_fd_sc_hd__o21a_2 abstract view
.subckt sky130_fd_sc_hd__o21a_2 A1 A2 B1 VGND VNB VPB VPWR X
.ends

* Black-box entry subcircuit for sky130_fd_sc_hd__decap_6 abstract view
.subckt sky130_fd_sc_hd__decap_6 VGND VNB VPB VPWR
.ends

* Black-box entry subcircuit for sky130_fd_sc_hd__a21o_1 abstract view
.subckt sky130_fd_sc_hd__a21o_1 A1 A2 B1 VGND VNB VPB VPWR X
.ends

* Black-box entry subcircuit for sky130_fd_sc_hd__a31o_1 abstract view
.subckt sky130_fd_sc_hd__a31o_1 A1 A2 A3 B1 VGND VNB VPB VPWR X
.ends

* Black-box entry subcircuit for sky130_fd_sc_hd__a31oi_1 abstract view
.subckt sky130_fd_sc_hd__a31oi_1 A1 A2 A3 B1 VGND VNB VPB VPWR Y
.ends

* Black-box entry subcircuit for sky130_fd_sc_hd__a211oi_1 abstract view
.subckt sky130_fd_sc_hd__a211oi_1 A1 A2 B1 C1 VGND VNB VPB VPWR Y
.ends

* Black-box entry subcircuit for sky130_fd_sc_hd__or4_1 abstract view
.subckt sky130_fd_sc_hd__or4_1 A B C D VGND VNB VPB VPWR X
.ends

* Black-box entry subcircuit for sky130_fd_sc_hd__clkbuf_4 abstract view
.subckt sky130_fd_sc_hd__clkbuf_4 A VGND VNB VPB VPWR X
.ends

* Black-box entry subcircuit for sky130_fd_sc_hd__buf_2 abstract view
.subckt sky130_fd_sc_hd__buf_2 A VGND VNB VPB VPWR X
.ends

* Black-box entry subcircuit for sky130_fd_sc_hd__and2b_1 abstract view
.subckt sky130_fd_sc_hd__and2b_1 A_N B VGND VNB VPB VPWR X
.ends

* Black-box entry subcircuit for sky130_fd_sc_hd__nor3_1 abstract view
.subckt sky130_fd_sc_hd__nor3_1 A B C VGND VNB VPB VPWR Y
.ends

* Black-box entry subcircuit for sky130_fd_sc_hd__or2_1 abstract view
.subckt sky130_fd_sc_hd__or2_1 A B VGND VNB VPB VPWR X
.ends

* Black-box entry subcircuit for sky130_fd_sc_hd__xnor2_1 abstract view
.subckt sky130_fd_sc_hd__xnor2_1 A B VGND VNB VPB VPWR Y
.ends

* Black-box entry subcircuit for sky130_fd_sc_hd__o311a_1 abstract view
.subckt sky130_fd_sc_hd__o311a_1 A1 A2 A3 B1 C1 VGND VNB VPB VPWR X
.ends

* Black-box entry subcircuit for sky130_fd_sc_hd__decap_8 abstract view
.subckt sky130_fd_sc_hd__decap_8 VGND VNB VPB VPWR
.ends

* Black-box entry subcircuit for sky130_fd_sc_hd__clkbuf_2 abstract view
.subckt sky130_fd_sc_hd__clkbuf_2 A VGND VNB VPB VPWR X
.ends

* Black-box entry subcircuit for sky130_fd_sc_hd__dfxtp_2 abstract view
.subckt sky130_fd_sc_hd__dfxtp_2 CLK D VGND VNB VPB VPWR Q
.ends

* Black-box entry subcircuit for sky130_fd_sc_hd__a21oi_1 abstract view
.subckt sky130_fd_sc_hd__a21oi_1 A1 A2 B1 VGND VNB VPB VPWR Y
.ends

* Black-box entry subcircuit for sky130_fd_sc_hd__o21a_1 abstract view
.subckt sky130_fd_sc_hd__o21a_1 A1 A2 B1 VGND VNB VPB VPWR X
.ends

* Black-box entry subcircuit for sky130_fd_sc_hd__or3_1 abstract view
.subckt sky130_fd_sc_hd__or3_1 A B C VGND VNB VPB VPWR X
.ends

* Black-box entry subcircuit for sky130_fd_sc_hd__buf_4 abstract view
.subckt sky130_fd_sc_hd__buf_4 A VGND VNB VPB VPWR X
.ends

* Black-box entry subcircuit for sky130_fd_sc_hd__inv_2 abstract view
.subckt sky130_fd_sc_hd__inv_2 A VGND VNB VPB VPWR Y
.ends

* Black-box entry subcircuit for sky130_fd_sc_hd__nor2_2 abstract view
.subckt sky130_fd_sc_hd__nor2_2 A B VGND VNB VPB VPWR Y
.ends

* Black-box entry subcircuit for sky130_fd_sc_hd__dlygate4sd3_1 abstract view
.subckt sky130_fd_sc_hd__dlygate4sd3_1 A VGND VNB VPB VPWR X
.ends

* Black-box entry subcircuit for sky130_fd_sc_hd__nor2_4 abstract view
.subckt sky130_fd_sc_hd__nor2_4 A B VGND VNB VPB VPWR Y
.ends

* Black-box entry subcircuit for sky130_fd_sc_hd__nand2_1 abstract view
.subckt sky130_fd_sc_hd__nand2_1 A B VGND VNB VPB VPWR Y
.ends

* Black-box entry subcircuit for sky130_fd_sc_hd__and3_1 abstract view
.subckt sky130_fd_sc_hd__and3_1 A B C VGND VNB VPB VPWR X
.ends

* Black-box entry subcircuit for sky130_fd_sc_hd__conb_1 abstract view
.subckt sky130_fd_sc_hd__conb_1 VGND VNB VPB VPWR HI LO
.ends

* Black-box entry subcircuit for sky130_fd_sc_hd__a21o_2 abstract view
.subckt sky130_fd_sc_hd__a21o_2 A1 A2 B1 VGND VNB VPB VPWR X
.ends

* Black-box entry subcircuit for sky130_fd_sc_hd__a41o_1 abstract view
.subckt sky130_fd_sc_hd__a41o_1 A1 A2 A3 A4 B1 VGND VNB VPB VPWR X
.ends

* Black-box entry subcircuit for sky130_fd_sc_hd__o31a_1 abstract view
.subckt sky130_fd_sc_hd__o31a_1 A1 A2 A3 B1 VGND VNB VPB VPWR X
.ends

* Black-box entry subcircuit for sky130_fd_sc_hd__a221o_1 abstract view
.subckt sky130_fd_sc_hd__a221o_1 A1 A2 B1 B2 C1 VGND VNB VPB VPWR X
.ends

* Black-box entry subcircuit for sky130_fd_sc_hd__a211o_1 abstract view
.subckt sky130_fd_sc_hd__a211o_1 A1 A2 B1 C1 VGND VNB VPB VPWR X
.ends

* Black-box entry subcircuit for sky130_fd_sc_hd__nand4_1 abstract view
.subckt sky130_fd_sc_hd__nand4_1 A B C D VGND VNB VPB VPWR Y
.ends

* Black-box entry subcircuit for sky130_fd_sc_hd__o211a_1 abstract view
.subckt sky130_fd_sc_hd__o211a_1 A1 A2 B1 C1 VGND VNB VPB VPWR X
.ends

* Black-box entry subcircuit for sky130_fd_sc_hd__o221a_1 abstract view
.subckt sky130_fd_sc_hd__o221a_1 A1 A2 B1 B2 C1 VGND VNB VPB VPWR X
.ends

* Black-box entry subcircuit for sky130_fd_sc_hd__a21oi_4 abstract view
.subckt sky130_fd_sc_hd__a21oi_4 A1 A2 B1 VGND VNB VPB VPWR Y
.ends

* Black-box entry subcircuit for sky130_fd_sc_hd__nor3b_1 abstract view
.subckt sky130_fd_sc_hd__nor3b_1 A B C_N VGND VNB VPB VPWR Y
.ends

* Black-box entry subcircuit for sky130_fd_sc_hd__clkbuf_16 abstract view
.subckt sky130_fd_sc_hd__clkbuf_16 A VGND VNB VPB VPWR X
.ends

* Black-box entry subcircuit for sky130_fd_sc_hd__o21ba_1 abstract view
.subckt sky130_fd_sc_hd__o21ba_1 A1 A2 B1_N VGND VNB VPB VPWR X
.ends

* Black-box entry subcircuit for sky130_fd_sc_hd__and3b_1 abstract view
.subckt sky130_fd_sc_hd__and3b_1 A_N B C VGND VNB VPB VPWR X
.ends

* Black-box entry subcircuit for sky130_fd_sc_hd__and4_1 abstract view
.subckt sky130_fd_sc_hd__and4_1 A B C D VGND VNB VPB VPWR X
.ends

* Black-box entry subcircuit for sky130_fd_sc_hd__and2_1 abstract view
.subckt sky130_fd_sc_hd__and2_1 A B VGND VNB VPB VPWR X
.ends

* Black-box entry subcircuit for sky130_fd_sc_hd__o21ai_1 abstract view
.subckt sky130_fd_sc_hd__o21ai_1 A1 A2 B1 VGND VNB VPB VPWR Y
.ends

* Black-box entry subcircuit for sky130_fd_sc_hd__a211o_2 abstract view
.subckt sky130_fd_sc_hd__a211o_2 A1 A2 B1 C1 VGND VNB VPB VPWR X
.ends

* Black-box entry subcircuit for sky130_fd_sc_hd__a21boi_1 abstract view
.subckt sky130_fd_sc_hd__a21boi_1 A1 A2 B1_N VGND VNB VPB VPWR Y
.ends

* Black-box entry subcircuit for sky130_fd_sc_hd__nor4_1 abstract view
.subckt sky130_fd_sc_hd__nor4_1 A B C D VGND VNB VPB VPWR Y
.ends

* Black-box entry subcircuit for sky130_fd_sc_hd__o211ai_1 abstract view
.subckt sky130_fd_sc_hd__o211ai_1 A1 A2 B1 C1 VGND VNB VPB VPWR Y
.ends

* Black-box entry subcircuit for sky130_fd_sc_hd__o22a_1 abstract view
.subckt sky130_fd_sc_hd__o22a_1 A1 A2 B1 B2 VGND VNB VPB VPWR X
.ends

* Black-box entry subcircuit for sky130_fd_sc_hd__a32o_1 abstract view
.subckt sky130_fd_sc_hd__a32o_1 A1 A2 A3 B1 B2 VGND VNB VPB VPWR X
.ends

* Black-box entry subcircuit for sky130_fd_sc_hd__buf_1 abstract view
.subckt sky130_fd_sc_hd__buf_1 A VGND VNB VPB VPWR X
.ends

* Black-box entry subcircuit for sky130_fd_sc_hd__a21bo_1 abstract view
.subckt sky130_fd_sc_hd__a21bo_1 A1 A2 B1_N VGND VNB VPB VPWR X
.ends

* Black-box entry subcircuit for sky130_fd_sc_hd__mux2_2 abstract view
.subckt sky130_fd_sc_hd__mux2_2 A0 A1 S VGND VNB VPB VPWR X
.ends

* Black-box entry subcircuit for sky130_fd_sc_hd__mux4_1 abstract view
.subckt sky130_fd_sc_hd__mux4_1 A0 A1 A2 A3 S0 S1 VGND VNB VPB VPWR X
.ends

* Black-box entry subcircuit for sky130_fd_sc_hd__nand3_1 abstract view
.subckt sky130_fd_sc_hd__nand3_1 A B C VGND VNB VPB VPWR Y
.ends

* Black-box entry subcircuit for sky130_fd_sc_hd__or3b_1 abstract view
.subckt sky130_fd_sc_hd__or3b_1 A B C_N VGND VNB VPB VPWR X
.ends

* Black-box entry subcircuit for sky130_fd_sc_hd__a311o_1 abstract view
.subckt sky130_fd_sc_hd__a311o_1 A1 A2 A3 B1 C1 VGND VNB VPB VPWR X
.ends

* Black-box entry subcircuit for sky130_fd_sc_hd__dfxtp_4 abstract view
.subckt sky130_fd_sc_hd__dfxtp_4 CLK D VGND VNB VPB VPWR Q
.ends

* Black-box entry subcircuit for sky130_fd_sc_hd__o211a_2 abstract view
.subckt sky130_fd_sc_hd__o211a_2 A1 A2 B1 C1 VGND VNB VPB VPWR X
.ends

* Black-box entry subcircuit for sky130_fd_sc_hd__or4b_1 abstract view
.subckt sky130_fd_sc_hd__or4b_1 A B C D_N VGND VNB VPB VPWR X
.ends

* Black-box entry subcircuit for sky130_fd_sc_hd__dlymetal6s2s_1 abstract view
.subckt sky130_fd_sc_hd__dlymetal6s2s_1 A VGND VNB VPB VPWR X
.ends

* Black-box entry subcircuit for sky130_fd_sc_hd__a31o_4 abstract view
.subckt sky130_fd_sc_hd__a31o_4 A1 A2 A3 B1 VGND VNB VPB VPWR X
.ends

* Black-box entry subcircuit for sky130_fd_sc_hd__or2_2 abstract view
.subckt sky130_fd_sc_hd__or2_2 A B VGND VNB VPB VPWR X
.ends

* Black-box entry subcircuit for sky130_fd_sc_hd__or4_2 abstract view
.subckt sky130_fd_sc_hd__or4_2 A B C D VGND VNB VPB VPWR X
.ends

* Black-box entry subcircuit for sky130_fd_sc_hd__or2b_1 abstract view
.subckt sky130_fd_sc_hd__or2b_1 A B_N VGND VNB VPB VPWR X
.ends

* Black-box entry subcircuit for sky130_fd_sc_hd__xor2_1 abstract view
.subckt sky130_fd_sc_hd__xor2_1 A B VGND VNB VPB VPWR X
.ends

* Black-box entry subcircuit for sky130_fd_sc_hd__o2111ai_1 abstract view
.subckt sky130_fd_sc_hd__o2111ai_1 A1 A2 B1 C1 D1 VGND VNB VPB VPWR Y
.ends

* Black-box entry subcircuit for sky130_fd_sc_hd__o2bb2a_1 abstract view
.subckt sky130_fd_sc_hd__o2bb2a_1 A1_N A2_N B1 B2 VGND VNB VPB VPWR X
.ends

* Black-box entry subcircuit for sky130_fd_sc_hd__a2bb2o_1 abstract view
.subckt sky130_fd_sc_hd__a2bb2o_1 A1_N A2_N B1 B2 VGND VNB VPB VPWR X
.ends

* Black-box entry subcircuit for sky130_fd_sc_hd__o2111a_1 abstract view
.subckt sky130_fd_sc_hd__o2111a_1 A1 A2 B1 C1 D1 VGND VNB VPB VPWR X
.ends

* Black-box entry subcircuit for sky130_fd_sc_hd__o32a_1 abstract view
.subckt sky130_fd_sc_hd__o32a_1 A1 A2 A3 B1 B2 VGND VNB VPB VPWR X
.ends

* Black-box entry subcircuit for sky130_fd_sc_hd__and2_2 abstract view
.subckt sky130_fd_sc_hd__and2_2 A B VGND VNB VPB VPWR X
.ends

* Black-box entry subcircuit for sky130_fd_sc_hd__nand2_4 abstract view
.subckt sky130_fd_sc_hd__nand2_4 A B VGND VNB VPB VPWR Y
.ends

* Black-box entry subcircuit for sky130_fd_sc_hd__diode_2 abstract view
.subckt sky130_fd_sc_hd__diode_2 DIODE VGND VNB VPB VPWR
.ends

* Black-box entry subcircuit for sky130_fd_sc_hd__nor3_2 abstract view
.subckt sky130_fd_sc_hd__nor3_2 A B C VGND VNB VPB VPWR Y
.ends

* Black-box entry subcircuit for sky130_fd_sc_hd__o21ai_2 abstract view
.subckt sky130_fd_sc_hd__o21ai_2 A1 A2 B1 VGND VNB VPB VPWR Y
.ends

.subckt serv_synth_wrapper VGND VPWR clk i_dbus_ack i_dbus_rdt[0] i_dbus_rdt[10] i_dbus_rdt[11]
+ i_dbus_rdt[12] i_dbus_rdt[13] i_dbus_rdt[14] i_dbus_rdt[15] i_dbus_rdt[16] i_dbus_rdt[17]
+ i_dbus_rdt[18] i_dbus_rdt[19] i_dbus_rdt[1] i_dbus_rdt[20] i_dbus_rdt[21] i_dbus_rdt[22]
+ i_dbus_rdt[23] i_dbus_rdt[24] i_dbus_rdt[25] i_dbus_rdt[26] i_dbus_rdt[27] i_dbus_rdt[28]
+ i_dbus_rdt[29] i_dbus_rdt[2] i_dbus_rdt[30] i_dbus_rdt[31] i_dbus_rdt[3] i_dbus_rdt[4]
+ i_dbus_rdt[5] i_dbus_rdt[6] i_dbus_rdt[7] i_dbus_rdt[8] i_dbus_rdt[9] i_ibus_ack
+ i_ibus_rdt[0] i_ibus_rdt[10] i_ibus_rdt[11] i_ibus_rdt[12] i_ibus_rdt[13] i_ibus_rdt[14]
+ i_ibus_rdt[15] i_ibus_rdt[16] i_ibus_rdt[17] i_ibus_rdt[18] i_ibus_rdt[19] i_ibus_rdt[1]
+ i_ibus_rdt[20] i_ibus_rdt[21] i_ibus_rdt[22] i_ibus_rdt[23] i_ibus_rdt[24] i_ibus_rdt[25]
+ i_ibus_rdt[26] i_ibus_rdt[27] i_ibus_rdt[28] i_ibus_rdt[29] i_ibus_rdt[2] i_ibus_rdt[30]
+ i_ibus_rdt[31] i_ibus_rdt[3] i_ibus_rdt[4] i_ibus_rdt[5] i_ibus_rdt[6] i_ibus_rdt[7]
+ i_ibus_rdt[8] i_ibus_rdt[9] i_rdata[0] i_rdata[1] i_rst i_timer_irq o_dbus_adr[0]
+ o_dbus_adr[10] o_dbus_adr[11] o_dbus_adr[12] o_dbus_adr[13] o_dbus_adr[14] o_dbus_adr[15]
+ o_dbus_adr[16] o_dbus_adr[17] o_dbus_adr[18] o_dbus_adr[19] o_dbus_adr[1] o_dbus_adr[20]
+ o_dbus_adr[21] o_dbus_adr[22] o_dbus_adr[23] o_dbus_adr[24] o_dbus_adr[25] o_dbus_adr[26]
+ o_dbus_adr[27] o_dbus_adr[28] o_dbus_adr[29] o_dbus_adr[2] o_dbus_adr[30] o_dbus_adr[31]
+ o_dbus_adr[3] o_dbus_adr[4] o_dbus_adr[5] o_dbus_adr[6] o_dbus_adr[7] o_dbus_adr[8]
+ o_dbus_adr[9] o_dbus_cyc o_dbus_dat[0] o_dbus_dat[10] o_dbus_dat[11] o_dbus_dat[12]
+ o_dbus_dat[13] o_dbus_dat[14] o_dbus_dat[15] o_dbus_dat[16] o_dbus_dat[17] o_dbus_dat[18]
+ o_dbus_dat[19] o_dbus_dat[1] o_dbus_dat[20] o_dbus_dat[21] o_dbus_dat[22] o_dbus_dat[23]
+ o_dbus_dat[24] o_dbus_dat[25] o_dbus_dat[26] o_dbus_dat[27] o_dbus_dat[28] o_dbus_dat[29]
+ o_dbus_dat[2] o_dbus_dat[30] o_dbus_dat[31] o_dbus_dat[3] o_dbus_dat[4] o_dbus_dat[5]
+ o_dbus_dat[6] o_dbus_dat[7] o_dbus_dat[8] o_dbus_dat[9] o_dbus_sel[0] o_dbus_sel[1]
+ o_dbus_sel[2] o_dbus_sel[3] o_dbus_we o_ibus_adr[0] o_ibus_adr[10] o_ibus_adr[11]
+ o_ibus_adr[12] o_ibus_adr[13] o_ibus_adr[14] o_ibus_adr[15] o_ibus_adr[16] o_ibus_adr[17]
+ o_ibus_adr[18] o_ibus_adr[19] o_ibus_adr[1] o_ibus_adr[20] o_ibus_adr[21] o_ibus_adr[22]
+ o_ibus_adr[23] o_ibus_adr[24] o_ibus_adr[25] o_ibus_adr[26] o_ibus_adr[27] o_ibus_adr[28]
+ o_ibus_adr[29] o_ibus_adr[2] o_ibus_adr[30] o_ibus_adr[31] o_ibus_adr[3] o_ibus_adr[4]
+ o_ibus_adr[5] o_ibus_adr[6] o_ibus_adr[7] o_ibus_adr[8] o_ibus_adr[9] o_ibus_cyc
+ o_raddr[0] o_raddr[1] o_raddr[2] o_raddr[3] o_raddr[4] o_raddr[5] o_raddr[6] o_raddr[7]
+ o_raddr[8] o_raddr[9] o_waddr[0] o_waddr[1] o_waddr[2] o_waddr[3] o_waddr[4] o_waddr[5]
+ o_waddr[6] o_waddr[7] o_waddr[8] o_waddr[9] o_wdata[0] o_wdata[1] o_wen
XTAP_177 VGND VPWR sky130_fd_sc_hd__tapvpwrvgnd_1
XTAP_188 VGND VPWR sky130_fd_sc_hd__tapvpwrvgnd_1
XTAP_199 VGND VPWR sky130_fd_sc_hd__tapvpwrvgnd_1
XFILLER_0_17_222 VGND VGND VPWR VPWR sky130_fd_sc_hd__fill_2
XFILLER_0_17_233 VGND VGND VPWR VPWR sky130_fd_sc_hd__decap_3
XFILLER_0_17_255 VGND VGND VPWR VPWR sky130_fd_sc_hd__decap_4
XFILLER_0_32_203 VGND VGND VPWR VPWR sky130_fd_sc_hd__fill_1
XFILLER_0_17_277 VGND VGND VPWR VPWR sky130_fd_sc_hd__decap_3
XFILLER_0_23_225 VPWR VGND VPWR VGND sky130_ef_sc_hd__decap_12
XFILLER_0_48_26 VGND VGND VPWR VPWR sky130_fd_sc_hd__fill_2
X_1270_ net102 net103 _0211_ VGND VGND VPWR VPWR _0214_ sky130_fd_sc_hd__mux2_1
XFILLER_0_13_51 VGND VGND VPWR VPWR sky130_fd_sc_hd__decap_4
X_0985_ net137 _0520_ _0523_ net148 VGND VGND VPWR VPWR _0034_ sky130_fd_sc_hd__a22o_1
XFILLER_0_1_141 VPWR VGND VPWR VGND sky130_ef_sc_hd__decap_12
XFILLER_0_14_203 VGND VGND VPWR VPWR sky130_fd_sc_hd__fill_1
X_1468_ clknet_4_12_0_clk _0130_ VGND VGND VPWR VPWR cpu.decode.op21 sky130_fd_sc_hd__dfxtp_1
X_1399_ clknet_4_14_0_clk _0064_ VGND VGND VPWR VPWR net160 sky130_fd_sc_hd__dfxtp_1
XFILLER_0_1_196 VPWR VGND VPWR VGND sky130_ef_sc_hd__decap_12
XFILLER_0_18_29 VGND VGND VPWR VPWR sky130_fd_sc_hd__fill_1
XFILLER_0_50_27 VGND VGND VPWR VPWR sky130_fd_sc_hd__fill_1
X_0770_ net137 cpu.ctrl.pc_plus_4_cy_r VGND VGND VPWR VPWR _0352_ sky130_fd_sc_hd__nor2_1
X_1322_ _0246_ VGND VGND VPWR VPWR _0170_ sky130_fd_sc_hd__clkbuf_1
X_1253_ net128 net129 _0189_ VGND VGND VPWR VPWR _0202_ sky130_fd_sc_hd__mux2_1
X_1184_ cpu.immdec.gen_immdec_w_eq_1.imm30_25\[1\] _0638_ _0636_ VGND VGND VPWR VPWR
+ _0639_ sky130_fd_sc_hd__mux2_1
XFILLER_0_24_50 VPWR VGND VPWR VGND sky130_ef_sc_hd__decap_12
Xclkbuf_4_12_0_clk clknet_0_clk VGND VGND VPWR VPWR clknet_4_12_0_clk sky130_fd_sc_hd__clkbuf_8
XFILLER_0_34_309 VGND VGND VPWR VPWR sky130_fd_sc_hd__fill_2
X_0968_ net193 _0457_ _0447_ VGND VGND VPWR VPWR _0512_ sky130_fd_sc_hd__o21a_2
XFILLER_0_6_277 VPWR VGND VPWR VGND sky130_ef_sc_hd__decap_12
X_0899_ _0460_ VGND VGND VPWR VPWR _0011_ sky130_fd_sc_hd__clkbuf_1
XFILLER_0_37_169 VGND VGND VPWR VPWR sky130_fd_sc_hd__decap_4
XFILLER_0_25_309 VGND VGND VPWR VPWR sky130_fd_sc_hd__fill_1
XFILLER_0_45_27 VGND VGND VPWR VPWR sky130_fd_sc_hd__fill_1
XFILLER_0_9_49 VGND VGND VPWR VPWR sky130_fd_sc_hd__decap_6
X_0822_ cpu.bufreg.data\[1\] _0399_ _0298_ VGND VGND VPWR VPWR net135 sky130_fd_sc_hd__a21o_1
X_0684_ _0276_ cpu.immdec.gen_immdec_w_eq_1.imm24_20\[2\] _0269_ _0277_ VGND VGND
+ VPWR VPWR net176 sky130_fd_sc_hd__a31o_1
X_0753_ cpu.bufreg.data\[0\] _0324_ _0326_ _0334_ VGND VGND VPWR VPWR _0335_ sky130_fd_sc_hd__a31oi_1
XFILLER_0_3_225 VPWR VGND VPWR VGND sky130_ef_sc_hd__decap_12
XFILLER_0_10_74 VGND VGND VPWR VPWR sky130_fd_sc_hd__fill_1
X_1305_ _0237_ VGND VGND VPWR VPWR _0162_ sky130_fd_sc_hd__clkbuf_1
X_1236_ _0190_ net2 _0579_ VGND VGND VPWR VPWR _0191_ sky130_fd_sc_hd__mux2_1
X_1167_ _0625_ cpu.immdec.gen_immdec_w_eq_1.imm19_12_20\[7\] _0610_ VGND VGND VPWR
+ VPWR _0626_ sky130_fd_sc_hd__mux2_1
X_1098_ net116 _0568_ _0574_ VGND VGND VPWR VPWR _0575_ sky130_fd_sc_hd__mux2_1
XFILLER_0_51_81 VPWR VGND VPWR VGND sky130_ef_sc_hd__decap_12
XFILLER_0_34_139 VGND VGND VPWR VPWR sky130_fd_sc_hd__fill_1
XFILLER_0_25_117 VGND VGND VPWR VPWR sky130_fd_sc_hd__fill_1
XFILLER_0_25_139 VGND VGND VPWR VPWR sky130_fd_sc_hd__fill_1
XFILLER_0_33_172 VPWR VGND VPWR VGND sky130_ef_sc_hd__decap_12
XFILLER_0_48_209 VGND VGND VPWR VPWR sky130_fd_sc_hd__fill_1
X_1021_ cpu.ctrl.i_jump _0340_ _0528_ _0268_ VGND VGND VPWR VPWR _0529_ sky130_fd_sc_hd__a211oi_1
XFILLER_0_12_301 VGND VGND VPWR VPWR sky130_fd_sc_hd__decap_6
XFILLER_0_21_73 VGND VGND VPWR VPWR sky130_fd_sc_hd__decap_3
X_0805_ cpu.bufreg.data\[0\] _0324_ _0386_ _0258_ VGND VGND VPWR VPWR _0387_ sky130_fd_sc_hd__a22o_1
X_0667_ cpu.decode.co_ebreak _0255_ _0262_ VGND VGND VPWR VPWR _0263_ sky130_fd_sc_hd__o21a_2
X_0736_ net123 _0303_ _0317_ VGND VGND VPWR VPWR _0318_ sky130_fd_sc_hd__mux2_1
X_1219_ _0181_ VGND VGND VPWR VPWR _0132_ sky130_fd_sc_hd__clkbuf_1
XFILLER_0_1_72 VGND VGND VPWR VPWR sky130_fd_sc_hd__decap_3
XFILLER_0_15_161 VGND VGND VPWR VPWR sky130_fd_sc_hd__decap_6
XFILLER_0_22_109 VGND VGND VPWR VPWR sky130_fd_sc_hd__fill_2
XFILLER_0_30_197 VPWR VGND VPWR VGND sky130_ef_sc_hd__decap_12
XFILLER_0_26_29 VPWR VGND VPWR VGND sky130_ef_sc_hd__decap_12
XFILLER_0_38_253 VGND VGND VPWR VPWR sky130_fd_sc_hd__decap_3
XFILLER_0_5_309 VGND VGND VPWR VPWR sky130_fd_sc_hd__fill_1
XTAP_348 VGND VPWR sky130_fd_sc_hd__tapvpwrvgnd_1
XTAP_337 VGND VPWR sky130_fd_sc_hd__tapvpwrvgnd_1
XTAP_326 VGND VPWR sky130_fd_sc_hd__tapvpwrvgnd_1
XTAP_315 VGND VPWR sky130_fd_sc_hd__tapvpwrvgnd_1
XTAP_304 VGND VPWR sky130_fd_sc_hd__tapvpwrvgnd_1
XFILLER_0_21_175 VPWR VGND VPWR VGND sky130_ef_sc_hd__decap_12
XTAP_359 VGND VPWR sky130_fd_sc_hd__tapvpwrvgnd_1
XFILLER_0_29_231 VGND VGND VPWR VPWR sky130_fd_sc_hd__fill_1
XFILLER_0_29_220 VGND VGND VPWR VPWR sky130_fd_sc_hd__decap_4
X_1004_ net145 _0524_ _0525_ net146 VGND VGND VPWR VPWR _0051_ sky130_fd_sc_hd__a22o_1
XFILLER_0_32_94 VGND VGND VPWR VPWR sky130_fd_sc_hd__decap_6
X_0719_ net118 net119 net116 net117 VGND VGND VPWR VPWR _0301_ sky130_fd_sc_hd__or4_1
XFILLER_0_12_197 VGND VGND VPWR VPWR sky130_fd_sc_hd__decap_6
XFILLER_0_35_201 VGND VGND VPWR VPWR sky130_fd_sc_hd__decap_3
Xoutput75 net75 VGND VGND VPWR VPWR o_dbus_adr[16] sky130_fd_sc_hd__clkbuf_4
Xoutput97 net97 VGND VGND VPWR VPWR o_dbus_adr[8] sky130_fd_sc_hd__clkbuf_4
Xoutput86 net86 VGND VGND VPWR VPWR o_dbus_adr[27] sky130_fd_sc_hd__buf_2
XFILLER_0_1_312 VGND VGND VPWR VPWR sky130_fd_sc_hd__fill_2
XTAP_145 VGND VPWR sky130_fd_sc_hd__tapvpwrvgnd_1
XTAP_134 VGND VPWR sky130_fd_sc_hd__tapvpwrvgnd_1
XTAP_123 VGND VPWR sky130_fd_sc_hd__tapvpwrvgnd_1
XTAP_112 VGND VPWR sky130_fd_sc_hd__tapvpwrvgnd_1
XTAP_156 VGND VPWR sky130_fd_sc_hd__tapvpwrvgnd_1
XTAP_167 VGND VPWR sky130_fd_sc_hd__tapvpwrvgnd_1
XTAP_178 VGND VPWR sky130_fd_sc_hd__tapvpwrvgnd_1
XTAP_189 VGND VPWR sky130_fd_sc_hd__tapvpwrvgnd_1
X_1484_ clknet_4_3_0_clk _0146_ VGND VGND VPWR VPWR net128 sky130_fd_sc_hd__dfxtp_1
XFILLER_0_17_212 VGND VGND VPWR VPWR sky130_fd_sc_hd__decap_6
XFILLER_0_17_245 VGND VGND VPWR VPWR sky130_fd_sc_hd__fill_1
XFILLER_0_23_19 VGND VGND VPWR VPWR sky130_fd_sc_hd__decap_4
XFILLER_0_23_237 VGND VGND VPWR VPWR sky130_fd_sc_hd__decap_4
XFILLER_0_3_18 VPWR VGND VPWR VGND sky130_ef_sc_hd__decap_12
X_0984_ _0522_ VGND VGND VPWR VPWR _0523_ sky130_fd_sc_hd__clkbuf_4
XFILLER_0_1_153 VPWR VGND VPWR VGND sky130_ef_sc_hd__decap_12
X_1467_ clknet_4_13_0_clk _0129_ VGND VGND VPWR VPWR cpu.decode.op22 sky130_fd_sc_hd__dfxtp_1
X_1398_ clknet_4_11_0_clk _0063_ VGND VGND VPWR VPWR net158 sky130_fd_sc_hd__dfxtp_1
XFILLER_0_9_220 VGND VGND VPWR VPWR sky130_fd_sc_hd__decap_4
XFILLER_0_34_29 VPWR VGND VPWR VGND sky130_ef_sc_hd__decap_12
X_1321_ net67 cpu.state.cnt_r\[0\] VGND VGND VPWR VPWR _0246_ sky130_fd_sc_hd__and2b_1
X_1252_ _0201_ VGND VGND VPWR VPWR _0145_ sky130_fd_sc_hd__clkbuf_1
X_1183_ cpu.immdec.gen_immdec_w_eq_1.imm30_25\[2\] net51 _0614_ VGND VGND VPWR VPWR
+ _0638_ sky130_fd_sc_hd__mux2_1
XFILLER_0_24_62 VGND VGND VPWR VPWR sky130_fd_sc_hd__decap_4
XFILLER_0_40_61 VPWR VGND VPWR VGND sky130_ef_sc_hd__decap_12
X_0967_ cpu.immdec.gen_immdec_w_eq_1.imm11_7\[1\] net62 _0419_ VGND VGND VPWR VPWR
+ _0511_ sky130_fd_sc_hd__mux2_1
XFILLER_0_6_289 VPWR VGND VPWR VGND sky130_ef_sc_hd__decap_12
XFILLER_0_49_81 VPWR VGND VPWR VGND sky130_ef_sc_hd__decap_12
X_0898_ rf_ram_if.wen0_r _0459_ _0252_ VGND VGND VPWR VPWR _0460_ sky130_fd_sc_hd__mux2_1
XFILLER_0_52_107 VGND VGND VPWR VPWR sky130_fd_sc_hd__decap_4
X_0752_ _0326_ _0331_ _0333_ VGND VGND VPWR VPWR _0334_ sky130_fd_sc_hd__nor3_1
X_0821_ cpu.bne_or_bge cpu.bufreg.data\[0\] VGND VGND VPWR VPWR _0399_ sky130_fd_sc_hd__or2_1
X_0683_ _0276_ cpu.immdec.gen_immdec_w_eq_1.imm19_12_20\[6\] VGND VGND VPWR VPWR _0277_
+ sky130_fd_sc_hd__and2b_1
XFILLER_0_3_237 VPWR VGND VPWR VGND sky130_ef_sc_hd__decap_12
X_1166_ cpu.immdec.gen_immdec_w_eq_1.imm19_12_20\[8\] net43 _0614_ VGND VGND VPWR
+ VPWR _0625_ sky130_fd_sc_hd__mux2_1
X_1304_ _0236_ net16 _0590_ VGND VGND VPWR VPWR _0237_ sky130_fd_sc_hd__mux2_1
X_1235_ net100 net111 _0189_ VGND VGND VPWR VPWR _0190_ sky130_fd_sc_hd__mux2_1
XFILLER_0_19_84 VGND VGND VPWR VPWR sky130_fd_sc_hd__fill_2
X_1097_ _0573_ VGND VGND VPWR VPWR _0574_ sky130_fd_sc_hd__buf_2
XFILLER_0_51_93 VGND VGND VPWR VPWR sky130_fd_sc_hd__fill_1
XFILLER_0_42_151 VGND VGND VPWR VPWR sky130_fd_sc_hd__fill_1
XFILLER_0_34_118 VGND VGND VPWR VPWR sky130_fd_sc_hd__fill_2
XFILLER_0_33_195 VGND VGND VPWR VPWR sky130_fd_sc_hd__decap_6
XFILLER_0_33_184 VGND VGND VPWR VPWR sky130_fd_sc_hd__decap_6
X_1020_ cpu.ctrl.i_jump _0356_ VGND VGND VPWR VPWR _0528_ sky130_fd_sc_hd__nor2_1
Xclkbuf_4_11_0_clk clknet_0_clk VGND VGND VPWR VPWR clknet_4_11_0_clk sky130_fd_sc_hd__clkbuf_8
XFILLER_0_8_307 VGND VGND VPWR VPWR sky130_fd_sc_hd__fill_1
X_0804_ _0381_ _0385_ VGND VGND VPWR VPWR _0386_ sky130_fd_sc_hd__xnor2_1
X_0735_ _0304_ _0308_ _0315_ _0316_ cpu.decode.opcode\[2\] VGND VGND VPWR VPWR _0317_
+ sky130_fd_sc_hd__o311a_1
XFILLER_0_24_184 VPWR VGND VPWR VGND sky130_ef_sc_hd__decap_12
X_0666_ _0258_ _0261_ VGND VGND VPWR VPWR _0262_ sky130_fd_sc_hd__and2b_1
X_1149_ _0613_ VGND VGND VPWR VPWR _0108_ sky130_fd_sc_hd__clkbuf_1
X_1218_ cpu.bne_or_bge net37 _0420_ VGND VGND VPWR VPWR _0181_ sky130_fd_sc_hd__mux2_1
XFILLER_0_1_95 VPWR VGND VPWR VGND sky130_ef_sc_hd__decap_12
XFILLER_0_15_173 VPWR VGND VPWR VGND sky130_ef_sc_hd__decap_12
XFILLER_0_42_18 VGND VGND VPWR VPWR sky130_fd_sc_hd__decap_6
XFILLER_0_38_265 VPWR VGND VPWR VGND sky130_ef_sc_hd__decap_12
XFILLER_0_38_243 VGND VGND VPWR VPWR sky130_fd_sc_hd__decap_8
XTAP_349 VGND VPWR sky130_fd_sc_hd__tapvpwrvgnd_1
XTAP_338 VGND VPWR sky130_fd_sc_hd__tapvpwrvgnd_1
XTAP_327 VGND VPWR sky130_fd_sc_hd__tapvpwrvgnd_1
XTAP_316 VGND VPWR sky130_fd_sc_hd__tapvpwrvgnd_1
XTAP_305 VGND VPWR sky130_fd_sc_hd__tapvpwrvgnd_1
XFILLER_0_6_29 VGND VGND VPWR VPWR sky130_fd_sc_hd__fill_1
XFILLER_0_21_187 VGND VGND VPWR VPWR sky130_fd_sc_hd__decap_6
X_1003_ net144 _0524_ _0525_ net145 VGND VGND VPWR VPWR _0050_ sky130_fd_sc_hd__a22o_1
XFILLER_0_16_52 VGND VGND VPWR VPWR sky130_fd_sc_hd__fill_1
XFILLER_0_16_85 VGND VGND VPWR VPWR sky130_fd_sc_hd__decap_4
XFILLER_0_44_246 VGND VGND VPWR VPWR sky130_fd_sc_hd__decap_3
XFILLER_0_32_51 VGND VGND VPWR VPWR sky130_fd_sc_hd__decap_6
X_0718_ cpu.bufreg.i_right_shift_op VGND VGND VPWR VPWR _0300_ sky130_fd_sc_hd__clkbuf_4
XFILLER_0_35_268 VPWR VGND VPWR VGND sky130_ef_sc_hd__decap_12
Xoutput76 net76 VGND VGND VPWR VPWR o_dbus_adr[17] sky130_fd_sc_hd__buf_2
Xoutput87 net87 VGND VGND VPWR VPWR o_dbus_adr[28] sky130_fd_sc_hd__clkbuf_4
Xoutput98 net98 VGND VGND VPWR VPWR o_dbus_adr[9] sky130_fd_sc_hd__clkbuf_4
XFILLER_0_41_205 VGND VGND VPWR VPWR sky130_fd_sc_hd__decap_3
XFILLER_0_5_129 VGND VGND VPWR VPWR sky130_fd_sc_hd__fill_1
XTAP_135 VGND VPWR sky130_fd_sc_hd__tapvpwrvgnd_1
XTAP_124 VGND VPWR sky130_fd_sc_hd__tapvpwrvgnd_1
XTAP_113 VGND VPWR sky130_fd_sc_hd__tapvpwrvgnd_1
XTAP_146 VGND VPWR sky130_fd_sc_hd__tapvpwrvgnd_1
XTAP_157 VGND VPWR sky130_fd_sc_hd__tapvpwrvgnd_1
XTAP_168 VGND VPWR sky130_fd_sc_hd__tapvpwrvgnd_1
X_1483_ clknet_4_2_0_clk _0145_ VGND VGND VPWR VPWR net127 sky130_fd_sc_hd__dfxtp_1
XTAP_179 VGND VPWR sky130_fd_sc_hd__tapvpwrvgnd_1
XFILLER_0_27_73 VPWR VGND VPWR VGND sky130_ef_sc_hd__decap_12
XFILLER_0_17_202 VGND VGND VPWR VPWR sky130_fd_sc_hd__fill_2
X_0983_ _0521_ VGND VGND VPWR VPWR _0522_ sky130_fd_sc_hd__clkbuf_2
XFILLER_0_13_64 VPWR VGND VPWR VGND sky130_ef_sc_hd__decap_12
XFILLER_0_1_165 VGND VGND VPWR VPWR sky130_fd_sc_hd__decap_3
XFILLER_0_14_249 VGND VGND VPWR VPWR sky130_fd_sc_hd__decap_3
XFILLER_0_38_72 VPWR VGND VPWR VGND sky130_ef_sc_hd__decap_12
X_1466_ clknet_4_8_0_clk _0128_ VGND VGND VPWR VPWR cpu.decode.op26 sky130_fd_sc_hd__dfxtp_1
X_1397_ clknet_4_10_0_clk _0062_ VGND VGND VPWR VPWR net157 sky130_fd_sc_hd__dfxtp_2
XFILLER_0_49_113 VPWR VGND VPWR VGND sky130_ef_sc_hd__decap_12
XFILLER_0_34_19 VGND VGND VPWR VPWR sky130_fd_sc_hd__decap_8
XFILLER_0_51_300 VGND VGND VPWR VPWR sky130_fd_sc_hd__fill_2
XFILLER_0_50_29 VPWR VGND VPWR VGND sky130_ef_sc_hd__decap_12
X_1320_ _0444_ _0245_ _0415_ VGND VGND VPWR VPWR _0169_ sky130_fd_sc_hd__a21oi_1
XFILLER_0_11_219 VGND VGND VPWR VPWR sky130_fd_sc_hd__fill_1
X_1251_ _0200_ net29 _0579_ VGND VGND VPWR VPWR _0201_ sky130_fd_sc_hd__mux2_1
X_1182_ _0637_ VGND VGND VPWR VPWR _0117_ sky130_fd_sc_hd__clkbuf_1
XFILLER_0_40_73 VGND VGND VPWR VPWR sky130_fd_sc_hd__decap_8
XFILLER_0_40_40 VGND VGND VPWR VPWR sky130_fd_sc_hd__decap_6
X_0966_ _0510_ VGND VGND VPWR VPWR _0028_ sky130_fd_sc_hd__clkbuf_1
XFILLER_0_6_213 VPWR VGND VPWR VGND sky130_ef_sc_hd__decap_12
X_0897_ _0266_ _0458_ _0397_ VGND VGND VPWR VPWR _0459_ sky130_fd_sc_hd__o21a_1
X_1449_ clknet_4_13_0_clk _0111_ VGND VGND VPWR VPWR cpu.csr_imm sky130_fd_sc_hd__dfxtp_1
XFILLER_0_4_73 VGND VGND VPWR VPWR sky130_fd_sc_hd__fill_2
XFILLER_0_37_149 VGND VGND VPWR VPWR sky130_fd_sc_hd__decap_4
XFILLER_0_37_116 VPWR VGND VPWR VGND sky130_ef_sc_hd__decap_12
XFILLER_0_51_141 VPWR VGND VPWR VGND sky130_ef_sc_hd__decap_12
X_0751_ _0312_ _0332_ _0311_ VGND VGND VPWR VPWR _0333_ sky130_fd_sc_hd__a21oi_1
XFILLER_0_3_249 VPWR VGND VPWR VGND sky130_ef_sc_hd__decap_12
XFILLER_0_9_18 VGND VGND VPWR VPWR sky130_fd_sc_hd__decap_3
XFILLER_0_10_32 VGND VGND VPWR VPWR sky130_fd_sc_hd__fill_1
X_0820_ rf_ram_if.rtrig1 rf_ram_if.wen0_r rf_ram_if.wen1_r _0276_ VGND VGND VPWR VPWR
+ net192 sky130_fd_sc_hd__a22o_1
XFILLER_0_51_196 VPWR VGND VPWR VGND sky130_ef_sc_hd__decap_12
X_1303_ net114 net115 _0572_ VGND VGND VPWR VPWR _0236_ sky130_fd_sc_hd__mux2_1
X_0682_ rf_ram_if.rtrig0 VGND VGND VPWR VPWR _0276_ sky130_fd_sc_hd__buf_2
X_1165_ _0624_ VGND VGND VPWR VPWR _0113_ sky130_fd_sc_hd__clkbuf_1
X_1096_ _0567_ _0565_ _0572_ VGND VGND VPWR VPWR _0573_ sky130_fd_sc_hd__or3_1
X_1234_ _0572_ VGND VGND VPWR VPWR _0189_ sky130_fd_sc_hd__buf_4
XFILLER_0_42_141 VGND VGND VPWR VPWR sky130_fd_sc_hd__fill_1
X_0949_ _0498_ VGND VGND VPWR VPWR _0023_ sky130_fd_sc_hd__clkbuf_1
XFILLER_0_0_219 VGND VGND VPWR VPWR sky130_fd_sc_hd__fill_1
XFILLER_0_21_20 VPWR VGND VPWR VGND sky130_ef_sc_hd__decap_12
X_0734_ _0298_ VGND VGND VPWR VPWR _0316_ sky130_fd_sc_hd__inv_2
X_0803_ _0383_ _0384_ VGND VGND VPWR VPWR _0385_ sky130_fd_sc_hd__nor2_1
X_0665_ _0259_ _0260_ VGND VGND VPWR VPWR _0261_ sky130_fd_sc_hd__nor2_2
XFILLER_0_46_83 VGND VGND VPWR VPWR sky130_fd_sc_hd__fill_1
X_1148_ _0612_ cpu.immdec.gen_immdec_w_eq_1.imm19_12_20\[1\] _0610_ VGND VGND VPWR
+ VPWR _0613_ sky130_fd_sc_hd__mux2_1
X_1079_ _0559_ VGND VGND VPWR VPWR _0092_ sky130_fd_sc_hd__clkbuf_1
X_1217_ _0448_ cpu.decode.co_ebreak _0606_ VGND VGND VPWR VPWR _0131_ sky130_fd_sc_hd__a21o_1
XFILLER_0_30_122 VGND VGND VPWR VPWR sky130_fd_sc_hd__decap_6
XFILLER_0_15_185 VGND VGND VPWR VPWR sky130_fd_sc_hd__decap_6
XFILLER_0_15_196 VGND VGND VPWR VPWR sky130_fd_sc_hd__decap_6
Xhold10 net143 VGND VGND VPWR VPWR net206 sky130_fd_sc_hd__dlygate4sd3_1
XFILLER_0_21_133 VGND VGND VPWR VPWR sky130_fd_sc_hd__fill_2
XTAP_339 VGND VPWR sky130_fd_sc_hd__tapvpwrvgnd_1
XTAP_328 VGND VPWR sky130_fd_sc_hd__tapvpwrvgnd_1
XTAP_317 VGND VPWR sky130_fd_sc_hd__tapvpwrvgnd_1
XTAP_306 VGND VPWR sky130_fd_sc_hd__tapvpwrvgnd_1
X_1002_ net143 _0524_ _0525_ net144 VGND VGND VPWR VPWR _0049_ sky130_fd_sc_hd__a22o_1
XFILLER_0_44_214 VPWR VGND VPWR VGND sky130_ef_sc_hd__decap_12
XFILLER_0_32_85 VGND VGND VPWR VPWR sky130_fd_sc_hd__decap_4
XFILLER_0_29_266 VGND VGND VPWR VPWR sky130_fd_sc_hd__fill_1
XFILLER_0_8_138 VGND VGND VPWR VPWR sky130_fd_sc_hd__fill_2
X_0717_ _0260_ _0298_ VGND VGND VPWR VPWR _0299_ sky130_fd_sc_hd__nor2_1
XFILLER_0_50_217 VGND VGND VPWR VPWR sky130_fd_sc_hd__fill_1
XFILLER_0_35_225 VGND VGND VPWR VPWR sky130_fd_sc_hd__decap_8
XFILLER_0_7_160 VGND VGND VPWR VPWR sky130_fd_sc_hd__decap_8
Xclkbuf_4_10_0_clk clknet_0_clk VGND VGND VPWR VPWR clknet_4_10_0_clk sky130_fd_sc_hd__clkbuf_8
Xoutput77 net77 VGND VGND VPWR VPWR o_dbus_adr[18] sky130_fd_sc_hd__clkbuf_4
Xoutput99 net99 VGND VGND VPWR VPWR o_dbus_cyc sky130_fd_sc_hd__clkbuf_4
Xoutput88 net88 VGND VGND VPWR VPWR o_dbus_adr[29] sky130_fd_sc_hd__clkbuf_4
XFILLER_0_5_108 VGND VGND VPWR VPWR sky130_fd_sc_hd__fill_1
XFILLER_0_26_247 VGND VGND VPWR VPWR sky130_fd_sc_hd__fill_1
XFILLER_0_26_269 VPWR VGND VPWR VGND sky130_ef_sc_hd__decap_12
XFILLER_0_41_217 VGND VGND VPWR VPWR sky130_fd_sc_hd__decap_4
XTAP_114 VGND VPWR sky130_fd_sc_hd__tapvpwrvgnd_1
X_1482_ clknet_4_8_0_clk _0144_ VGND VGND VPWR VPWR net126 sky130_fd_sc_hd__dfxtp_1
XTAP_136 VGND VPWR sky130_fd_sc_hd__tapvpwrvgnd_1
XTAP_125 VGND VPWR sky130_fd_sc_hd__tapvpwrvgnd_1
XTAP_147 VGND VPWR sky130_fd_sc_hd__tapvpwrvgnd_1
XTAP_158 VGND VPWR sky130_fd_sc_hd__tapvpwrvgnd_1
XTAP_169 VGND VPWR sky130_fd_sc_hd__tapvpwrvgnd_1
XFILLER_0_27_85 VGND VGND VPWR VPWR sky130_fd_sc_hd__decap_3
XFILLER_0_43_95 VGND VGND VPWR VPWR sky130_fd_sc_hd__decap_8
XFILLER_0_43_73 VGND VGND VPWR VPWR sky130_fd_sc_hd__fill_1
XFILLER_0_4_141 VGND VGND VPWR VPWR sky130_fd_sc_hd__decap_6
XFILLER_0_17_225 VGND VGND VPWR VPWR sky130_fd_sc_hd__decap_8
XFILLER_0_17_269 VGND VGND VPWR VPWR sky130_fd_sc_hd__decap_8
XFILLER_0_7_51 VGND VGND VPWR VPWR sky130_fd_sc_hd__decap_4
XFILLER_0_48_29 VPWR VGND VPWR VGND sky130_ef_sc_hd__decap_12
XFILLER_0_48_18 VGND VGND VPWR VPWR sky130_fd_sc_hd__decap_8
XFILLER_0_46_309 VGND VGND VPWR VPWR sky130_fd_sc_hd__decap_4
X_0982_ net67 _0402_ VGND VGND VPWR VPWR _0521_ sky130_fd_sc_hd__and2b_1
XFILLER_0_13_76 VPWR VGND VPWR VGND sky130_ef_sc_hd__decap_12
X_1465_ clknet_4_15_0_clk _0127_ VGND VGND VPWR VPWR cpu.immdec.gen_immdec_w_eq_1.imm24_20\[4\]
+ sky130_fd_sc_hd__dfxtp_1
XFILLER_0_38_62 VGND VGND VPWR VPWR sky130_fd_sc_hd__fill_1
XFILLER_0_38_40 VGND VGND VPWR VPWR sky130_fd_sc_hd__decap_3
XFILLER_0_1_111 VGND VGND VPWR VPWR sky130_fd_sc_hd__fill_1
XFILLER_0_22_261 VGND VGND VPWR VPWR sky130_fd_sc_hd__fill_1
X_1396_ clknet_4_10_0_clk _0061_ VGND VGND VPWR VPWR net156 sky130_fd_sc_hd__dfxtp_1
XFILLER_0_49_136 VPWR VGND VPWR VGND sky130_ef_sc_hd__decap_12
XFILLER_0_49_125 VGND VGND VPWR VPWR sky130_fd_sc_hd__decap_8
XFILLER_0_37_309 VGND VGND VPWR VPWR sky130_fd_sc_hd__fill_1
XFILLER_0_28_309 VGND VGND VPWR VPWR sky130_fd_sc_hd__decap_4
XFILLER_0_51_312 VGND VGND VPWR VPWR sky130_fd_sc_hd__fill_2
X_1250_ net127 net128 _0189_ VGND VGND VPWR VPWR _0200_ sky130_fd_sc_hd__mux2_1
X_1181_ cpu.immdec.gen_immdec_w_eq_1.imm30_25\[0\] _0634_ _0636_ VGND VGND VPWR VPWR
+ _0637_ sky130_fd_sc_hd__mux2_1
XFILLER_0_46_128 VPWR VGND VPWR VGND sky130_ef_sc_hd__decap_12
XFILLER_0_46_117 VGND VGND VPWR VPWR sky130_fd_sc_hd__fill_2
XFILLER_0_6_225 VGND VGND VPWR VPWR sky130_fd_sc_hd__fill_2
XFILLER_0_19_309 VGND VGND VPWR VPWR sky130_fd_sc_hd__decap_4
XFILLER_0_24_20 VGND VGND VPWR VPWR sky130_fd_sc_hd__decap_8
X_0965_ cpu.gen_csr.csr.mcause3_0\[3\] _0509_ _0503_ VGND VGND VPWR VPWR _0510_ sky130_fd_sc_hd__mux2_1
X_0896_ cpu.immdec.gen_immdec_w_eq_1.imm11_7\[0\] cpu.immdec.gen_immdec_w_eq_1.imm11_7\[1\]
+ _0455_ _0457_ _0401_ VGND VGND VPWR VPWR _0458_ sky130_fd_sc_hd__o311a_1
XFILLER_0_6_236 VPWR VGND VPWR VGND sky130_ef_sc_hd__decap_12
X_1448_ clknet_4_13_0_clk _0110_ VGND VGND VPWR VPWR cpu.immdec.gen_immdec_w_eq_1.imm19_12_20\[3\]
+ sky130_fd_sc_hd__dfxtp_1
XFILLER_0_4_41 VPWR VGND VPWR VGND sky130_ef_sc_hd__decap_12
XFILLER_0_10_253 VPWR VGND VPWR VGND sky130_ef_sc_hd__decap_12
X_1379_ clknet_4_1_0_clk _0044_ VGND VGND VPWR VPWR net138 sky130_fd_sc_hd__dfxtp_1
XFILLER_0_45_194 VGND VGND VPWR VPWR sky130_fd_sc_hd__decap_8
XFILLER_0_37_128 VGND VGND VPWR VPWR sky130_fd_sc_hd__decap_6
XFILLER_0_51_153 VPWR VGND VPWR VGND sky130_ef_sc_hd__decap_12
X_0750_ cpu.bufreg2.i_bytecnt\[0\] VGND VGND VPWR VPWR _0332_ sky130_fd_sc_hd__clkbuf_4
X_0681_ _0275_ VGND VGND VPWR VPWR net175 sky130_fd_sc_hd__clkbuf_1
XFILLER_0_10_11 VGND VGND VPWR VPWR sky130_fd_sc_hd__decap_8
X_1302_ _0235_ VGND VGND VPWR VPWR _0161_ sky130_fd_sc_hd__clkbuf_1
XFILLER_0_19_20 VGND VGND VPWR VPWR sky130_fd_sc_hd__decap_8
X_1233_ _0188_ VGND VGND VPWR VPWR _0139_ sky130_fd_sc_hd__clkbuf_1
X_1164_ _0623_ cpu.immdec.gen_immdec_w_eq_1.imm19_12_20\[6\] _0610_ VGND VGND VPWR
+ VPWR _0624_ sky130_fd_sc_hd__mux2_1
X_1095_ net196 _0571_ VGND VGND VPWR VPWR _0572_ sky130_fd_sc_hd__nor2_4
X_0948_ cpu.gen_csr.csr.mstatus_mpie cpu.gen_csr.csr.mstatus_mie _0486_ VGND VGND
+ VPWR VPWR _0498_ sky130_fd_sc_hd__mux2_1
XFILLER_0_34_109 VGND VGND VPWR VPWR sky130_fd_sc_hd__fill_1
XFILLER_0_19_106 VGND VGND VPWR VPWR sky130_fd_sc_hd__decap_3
X_0879_ rf_ram_if.rtrig0 net170 VGND VGND VPWR VPWR _0445_ sky130_fd_sc_hd__nand2_1
XFILLER_0_18_194 VGND VGND VPWR VPWR sky130_fd_sc_hd__fill_2
XFILLER_0_8_309 VGND VGND VPWR VPWR sky130_fd_sc_hd__decap_4
X_0802_ _0370_ _0372_ _0382_ VGND VGND VPWR VPWR _0384_ sky130_fd_sc_hd__and3_1
XFILLER_0_21_32 VGND VGND VPWR VPWR sky130_fd_sc_hd__decap_6
X_0733_ _0309_ _0314_ VGND VGND VPWR VPWR _0315_ sky130_fd_sc_hd__nor2_1
XFILLER_0_24_175 VGND VGND VPWR VPWR sky130_fd_sc_hd__decap_6
XFILLER_0_24_197 VGND VGND VPWR VPWR sky130_fd_sc_hd__decap_8
X_0664_ cpu.decode.opcode\[2\] VGND VGND VPWR VPWR _0260_ sky130_fd_sc_hd__inv_2
X_1216_ _0448_ cpu.decode.op21 _0175_ VGND VGND VPWR VPWR _0130_ sky130_fd_sc_hd__a21o_1
XFILLER_0_47_223 VGND VGND VPWR VPWR sky130_fd_sc_hd__fill_1
X_1147_ cpu.immdec.gen_immdec_w_eq_1.imm19_12_20\[2\] net37 _0419_ VGND VGND VPWR
+ VPWR _0612_ sky130_fd_sc_hd__mux2_1
X_1078_ net87 net88 _0550_ VGND VGND VPWR VPWR _0559_ sky130_fd_sc_hd__mux2_1
XFILLER_0_47_267 VGND VGND VPWR VPWR sky130_fd_sc_hd__fill_1
Xhold11 net156 VGND VGND VPWR VPWR net207 sky130_fd_sc_hd__dlygate4sd3_1
XFILLER_0_21_101 VGND VGND VPWR VPWR sky130_fd_sc_hd__decap_8
XFILLER_0_21_167 VGND VGND VPWR VPWR sky130_fd_sc_hd__fill_1
XTAP_329 VGND VPWR sky130_fd_sc_hd__tapvpwrvgnd_1
XTAP_318 VGND VPWR sky130_fd_sc_hd__tapvpwrvgnd_1
XTAP_307 VGND VPWR sky130_fd_sc_hd__tapvpwrvgnd_1
X_1001_ net142 _0524_ _0525_ net206 VGND VGND VPWR VPWR _0048_ sky130_fd_sc_hd__a22o_1
XFILLER_0_16_76 VGND VGND VPWR VPWR sky130_fd_sc_hd__decap_8
XFILLER_0_52_281 VGND VGND VPWR VPWR sky130_fd_sc_hd__fill_2
XFILLER_0_44_226 VPWR VGND VPWR VGND sky130_ef_sc_hd__decap_12
XFILLER_0_29_278 VGND VGND VPWR VPWR sky130_fd_sc_hd__fill_2
XFILLER_0_4_301 VGND VGND VPWR VPWR sky130_fd_sc_hd__decap_6
XFILLER_0_8_128 VGND VGND VPWR VPWR sky130_fd_sc_hd__fill_2
X_0716_ cpu.decode.co_mem_word VGND VGND VPWR VPWR _0298_ sky130_fd_sc_hd__clkbuf_4
XFILLER_0_32_3 VGND VGND VPWR VPWR sky130_fd_sc_hd__fill_2
XFILLER_0_35_215 VGND VGND VPWR VPWR sky130_fd_sc_hd__decap_3
XFILLER_0_43_281 VPWR VGND VPWR VGND sky130_ef_sc_hd__decap_12
Xoutput78 net78 VGND VGND VPWR VPWR o_dbus_adr[19] sky130_fd_sc_hd__clkbuf_4
Xoutput89 net89 VGND VGND VPWR VPWR o_dbus_adr[2] sky130_fd_sc_hd__clkbuf_4
X_1481_ clknet_4_13_0_clk _0143_ VGND VGND VPWR VPWR net125 sky130_fd_sc_hd__dfxtp_1
XTAP_137 VGND VPWR sky130_fd_sc_hd__tapvpwrvgnd_1
XTAP_126 VGND VPWR sky130_fd_sc_hd__tapvpwrvgnd_1
XTAP_115 VGND VPWR sky130_fd_sc_hd__tapvpwrvgnd_1
XTAP_148 VGND VPWR sky130_fd_sc_hd__tapvpwrvgnd_1
XTAP_159 VGND VPWR sky130_fd_sc_hd__tapvpwrvgnd_1
XFILLER_0_27_53 VGND VGND VPWR VPWR sky130_fd_sc_hd__decap_3
XFILLER_0_40_262 VPWR VGND VPWR VGND sky130_ef_sc_hd__decap_12
XFILLER_0_4_197 VPWR VGND VPWR VGND sky130_ef_sc_hd__decap_12
XFILLER_0_17_259 VGND VGND VPWR VPWR sky130_fd_sc_hd__fill_1
XFILLER_0_16_292 VGND VGND VPWR VPWR sky130_fd_sc_hd__fill_1
XFILLER_0_13_55 VGND VGND VPWR VPWR sky130_fd_sc_hd__fill_1
X_0981_ _0453_ VGND VGND VPWR VPWR _0520_ sky130_fd_sc_hd__clkbuf_4
Xserv_synth_wrapper_194 VGND VGND VPWR VPWR serv_synth_wrapper_194/HI o_dbus_adr[0]
+ sky130_fd_sc_hd__conb_1
XFILLER_0_13_88 VGND VGND VPWR VPWR sky130_fd_sc_hd__decap_8
XFILLER_0_14_207 VPWR VGND VPWR VGND sky130_ef_sc_hd__decap_12
X_1464_ clknet_4_15_0_clk _0126_ VGND VGND VPWR VPWR cpu.immdec.gen_immdec_w_eq_1.imm24_20\[3\]
+ sky130_fd_sc_hd__dfxtp_1
X_1395_ clknet_4_11_0_clk _0060_ VGND VGND VPWR VPWR net155 sky130_fd_sc_hd__dfxtp_1
XFILLER_0_22_295 VPWR VGND VPWR VGND sky130_ef_sc_hd__decap_12
XFILLER_0_49_148 VPWR VGND VPWR VGND sky130_ef_sc_hd__decap_12
XFILLER_0_48_192 VGND VGND VPWR VPWR sky130_fd_sc_hd__decap_4
X_1180_ _0397_ _0635_ net34 VGND VGND VPWR VPWR _0636_ sky130_fd_sc_hd__a21o_2
XFILLER_0_42_313 VGND VGND VPWR VPWR sky130_fd_sc_hd__fill_1
XFILLER_0_39_181 VGND VGND VPWR VPWR sky130_fd_sc_hd__decap_4
X_0964_ _0254_ _0363_ _0258_ _0261_ _0395_ VGND VGND VPWR VPWR _0509_ sky130_fd_sc_hd__a41o_1
XFILLER_0_6_248 VGND VGND VPWR VPWR sky130_fd_sc_hd__decap_4
XFILLER_0_24_76 VGND VGND VPWR VPWR sky130_fd_sc_hd__fill_1
X_0895_ _0325_ _0456_ _0388_ VGND VGND VPWR VPWR _0457_ sky130_fd_sc_hd__a21o_1
X_1447_ clknet_4_13_0_clk _0109_ VGND VGND VPWR VPWR cpu.immdec.gen_immdec_w_eq_1.imm19_12_20\[2\]
+ sky130_fd_sc_hd__dfxtp_1
XFILLER_0_4_97 VPWR VGND VPWR VGND sky130_ef_sc_hd__decap_12
XFILLER_0_4_53 VPWR VGND VPWR VGND sky130_ef_sc_hd__decap_12
XFILLER_0_10_265 VPWR VGND VPWR VGND sky130_ef_sc_hd__decap_12
X_1378_ clknet_4_1_0_clk _0043_ VGND VGND VPWR VPWR net168 sky130_fd_sc_hd__dfxtp_1
XFILLER_0_45_173 VGND VGND VPWR VPWR sky130_fd_sc_hd__fill_1
XFILLER_0_45_151 VPWR VGND VPWR VGND sky130_ef_sc_hd__decap_12
XFILLER_0_33_313 VGND VGND VPWR VPWR sky130_fd_sc_hd__fill_1
XFILLER_0_5_281 VPWR VGND VPWR VGND sky130_ef_sc_hd__decap_12
XFILLER_0_51_165 VGND VGND VPWR VPWR sky130_fd_sc_hd__decap_3
X_0680_ cpu.immdec.gen_immdec_w_eq_1.imm19_12_20\[5\] _0274_ _0252_ VGND VGND VPWR
+ VPWR _0275_ sky130_fd_sc_hd__mux2_1
XFILLER_0_10_56 VPWR VGND VPWR VGND sky130_ef_sc_hd__decap_12
XFILLER_0_10_78 VGND VGND VPWR VPWR sky130_fd_sc_hd__decap_6
X_1301_ _0234_ net15 _0590_ VGND VGND VPWR VPWR _0235_ sky130_fd_sc_hd__mux2_1
X_1232_ _0288_ net61 _0515_ VGND VGND VPWR VPWR _0188_ sky130_fd_sc_hd__mux2_1
X_1163_ cpu.immdec.gen_immdec_w_eq_1.imm19_12_20\[7\] net42 _0614_ VGND VGND VPWR
+ VPWR _0623_ sky130_fd_sc_hd__mux2_1
X_1094_ _0311_ _0332_ _0401_ _0570_ VGND VGND VPWR VPWR _0571_ sky130_fd_sc_hd__o31a_1
XFILLER_0_51_41 VPWR VGND VPWR VGND sky130_ef_sc_hd__decap_12
X_0947_ _0497_ VGND VGND VPWR VPWR _0022_ sky130_fd_sc_hd__clkbuf_1
XFILLER_0_2_251 VGND VGND VPWR VPWR sky130_fd_sc_hd__fill_1
X_0878_ _0290_ _0434_ _0436_ _0443_ VGND VGND VPWR VPWR _0444_ sky130_fd_sc_hd__o31a_1
XFILLER_0_33_110 VGND VGND VPWR VPWR sky130_fd_sc_hd__fill_2
X_0801_ _0370_ _0372_ _0382_ VGND VGND VPWR VPWR _0383_ sky130_fd_sc_hd__a21oi_1
X_0732_ _0313_ VGND VGND VPWR VPWR _0314_ sky130_fd_sc_hd__clkbuf_4
X_0663_ cpu.branch_op VGND VGND VPWR VPWR _0259_ sky130_fd_sc_hd__inv_2
XFILLER_0_46_41 VPWR VGND VPWR VGND sky130_ef_sc_hd__decap_12
X_1215_ _0448_ cpu.decode.op22 _0176_ VGND VGND VPWR VPWR _0129_ sky130_fd_sc_hd__a21o_1
X_1146_ _0611_ VGND VGND VPWR VPWR _0107_ sky130_fd_sc_hd__clkbuf_1
X_1077_ _0558_ VGND VGND VPWR VPWR _0091_ sky130_fd_sc_hd__clkbuf_1
XFILLER_0_15_110 VGND VGND VPWR VPWR sky130_fd_sc_hd__fill_2
XFILLER_0_38_224 VGND VGND VPWR VPWR sky130_fd_sc_hd__fill_2
XTAP_319 VGND VPWR sky130_fd_sc_hd__tapvpwrvgnd_1
XTAP_308 VGND VPWR sky130_fd_sc_hd__tapvpwrvgnd_1
XFILLER_0_21_113 VPWR VGND VPWR VGND sky130_ef_sc_hd__decap_12
X_1000_ net141 _0524_ _0525_ net142 VGND VGND VPWR VPWR _0047_ sky130_fd_sc_hd__a22o_1
XFILLER_0_29_246 VGND VGND VPWR VPWR sky130_fd_sc_hd__fill_1
XFILLER_0_8_107 VGND VGND VPWR VPWR sky130_fd_sc_hd__decap_6
XFILLER_0_8_118 VGND VGND VPWR VPWR sky130_fd_sc_hd__decap_6
XFILLER_0_44_238 VGND VGND VPWR VPWR sky130_fd_sc_hd__decap_8
X_0715_ _0295_ _0296_ VGND VGND VPWR VPWR _0297_ sky130_fd_sc_hd__or2_1
XFILLER_0_12_124 VGND VGND VPWR VPWR sky130_fd_sc_hd__decap_8
XFILLER_0_12_135 VGND VGND VPWR VPWR sky130_fd_sc_hd__decap_4
X_1129_ net124 net25 _0567_ VGND VGND VPWR VPWR _0600_ sky130_fd_sc_hd__mux2_1
XFILLER_0_28_290 VPWR VGND VPWR VGND sky130_ef_sc_hd__decap_12
XFILLER_0_43_293 VGND VGND VPWR VPWR sky130_fd_sc_hd__decap_4
Xoutput79 net79 VGND VGND VPWR VPWR o_dbus_adr[20] sky130_fd_sc_hd__clkbuf_4
XFILLER_0_34_293 VPWR VGND VPWR VGND sky130_ef_sc_hd__decap_12
XFILLER_0_26_227 VGND VGND VPWR VPWR sky130_fd_sc_hd__fill_2
X_1480_ clknet_4_13_0_clk _0142_ VGND VGND VPWR VPWR net122 sky130_fd_sc_hd__dfxtp_2
XTAP_138 VGND VPWR sky130_fd_sc_hd__tapvpwrvgnd_1
XTAP_127 VGND VPWR sky130_fd_sc_hd__tapvpwrvgnd_1
XTAP_116 VGND VPWR sky130_fd_sc_hd__tapvpwrvgnd_1
XTAP_149 VGND VPWR sky130_fd_sc_hd__tapvpwrvgnd_1
XFILLER_0_27_65 VGND VGND VPWR VPWR sky130_fd_sc_hd__fill_2
XFILLER_0_40_274 VPWR VGND VPWR VGND sky130_ef_sc_hd__decap_12
XFILLER_0_40_230 VPWR VGND VPWR VGND sky130_ef_sc_hd__decap_12
XFILLER_0_7_75 VGND VGND VPWR VPWR sky130_fd_sc_hd__fill_1
X_0980_ cpu.immdec.gen_immdec_w_eq_1.imm11_7\[4\] _0512_ _0514_ cpu.immdec.gen_immdec_w_eq_1.imm30_25\[0\]
+ _0519_ VGND VGND VPWR VPWR _0033_ sky130_fd_sc_hd__a221o_1
Xserv_synth_wrapper_195 VGND VGND VPWR VPWR serv_synth_wrapper_195/HI o_dbus_adr[1]
+ sky130_fd_sc_hd__conb_1
XFILLER_0_1_113 VGND VGND VPWR VPWR sky130_fd_sc_hd__decap_3
XFILLER_0_14_219 VGND VGND VPWR VPWR sky130_fd_sc_hd__decap_3
X_1463_ clknet_4_14_0_clk _0125_ VGND VGND VPWR VPWR cpu.immdec.gen_immdec_w_eq_1.imm24_20\[2\]
+ sky130_fd_sc_hd__dfxtp_1
X_1394_ clknet_4_10_0_clk _0059_ VGND VGND VPWR VPWR net154 sky130_fd_sc_hd__dfxtp_1
XFILLER_0_9_279 VGND VGND VPWR VPWR sky130_fd_sc_hd__fill_1
XFILLER_0_24_44 VGND VGND VPWR VPWR sky130_fd_sc_hd__decap_3
XFILLER_0_24_66 VGND VGND VPWR VPWR sky130_fd_sc_hd__fill_1
X_0963_ _0508_ VGND VGND VPWR VPWR _0027_ sky130_fd_sc_hd__clkbuf_1
X_0894_ _0307_ net136 VGND VGND VPWR VPWR _0456_ sky130_fd_sc_hd__nand2_1
XFILLER_0_49_96 VPWR VGND VPWR VGND sky130_ef_sc_hd__decap_12
X_1515_ net170 VGND VGND VPWR VPWR net180 sky130_fd_sc_hd__clkbuf_1
XFILLER_0_10_233 VGND VGND VPWR VPWR sky130_fd_sc_hd__decap_8
XFILLER_0_10_244 VGND VGND VPWR VPWR sky130_fd_sc_hd__decap_8
XFILLER_0_10_277 VPWR VGND VPWR VGND sky130_ef_sc_hd__decap_12
X_1446_ clknet_4_12_0_clk _0108_ VGND VGND VPWR VPWR cpu.immdec.gen_immdec_w_eq_1.imm19_12_20\[1\]
+ sky130_fd_sc_hd__dfxtp_1
XFILLER_0_4_65 VGND VGND VPWR VPWR sky130_fd_sc_hd__decap_8
XFILLER_0_4_21 VGND VGND VPWR VPWR sky130_fd_sc_hd__decap_6
X_1377_ clknet_4_4_0_clk _0042_ VGND VGND VPWR VPWR net167 sky130_fd_sc_hd__dfxtp_1
XFILLER_0_45_163 VGND VGND VPWR VPWR sky130_fd_sc_hd__decap_4
XFILLER_0_5_293 VPWR VGND VPWR VGND sky130_ef_sc_hd__decap_12
XFILLER_0_36_152 VPWR VGND VPWR VGND sky130_ef_sc_hd__decap_12
XFILLER_0_10_68 VGND VGND VPWR VPWR sky130_fd_sc_hd__decap_6
X_1162_ _0622_ VGND VGND VPWR VPWR _0112_ sky130_fd_sc_hd__clkbuf_1
X_1231_ _0187_ VGND VGND VPWR VPWR _0138_ sky130_fd_sc_hd__clkbuf_1
X_1300_ net113 net114 _0572_ VGND VGND VPWR VPWR _0234_ sky130_fd_sc_hd__mux2_1
XFILLER_0_51_53 VGND VGND VPWR VPWR sky130_fd_sc_hd__decap_3
XFILLER_0_35_98 VGND VGND VPWR VPWR sky130_fd_sc_hd__decap_3
X_1093_ _0311_ cpu.bufreg.data\[1\] _0299_ _0569_ VGND VGND VPWR VPWR _0570_ sky130_fd_sc_hd__a211o_1
XFILLER_0_51_97 VPWR VGND VPWR VGND sky130_ef_sc_hd__decap_12
XFILLER_0_42_177 VGND VGND VPWR VPWR sky130_fd_sc_hd__decap_3
X_0946_ net67 _0496_ VGND VGND VPWR VPWR _0497_ sky130_fd_sc_hd__and2b_1
X_0877_ _0305_ _0440_ _0442_ net1 VGND VGND VPWR VPWR _0443_ sky130_fd_sc_hd__a211oi_1
XFILLER_0_27_185 VGND VGND VPWR VPWR sky130_fd_sc_hd__fill_2
X_1429_ clknet_4_5_0_clk _0092_ VGND VGND VPWR VPWR net87 sky130_fd_sc_hd__dfxtp_1
XFILLER_0_18_174 VPWR VGND VPWR VGND sky130_ef_sc_hd__decap_12
X_0731_ _0310_ _0311_ _0312_ cpu.bufreg2.i_bytecnt\[0\] VGND VGND VPWR VPWR _0313_
+ sky130_fd_sc_hd__nand4_1
X_0800_ net136 cpu.bufreg.i_sh_signed _0257_ cpu.branch_op VGND VGND VPWR VPWR _0382_
+ sky130_fd_sc_hd__a211o_1
XFILLER_0_41_9 VPWR VGND VPWR VGND sky130_ef_sc_hd__decap_12
X_0662_ cpu.bufreg.i_right_shift_op _0257_ VGND VGND VPWR VPWR _0258_ sky130_fd_sc_hd__nor2_2
XFILLER_0_46_97 VPWR VGND VPWR VGND sky130_ef_sc_hd__decap_12
XFILLER_0_46_53 VPWR VGND VPWR VGND sky130_ef_sc_hd__decap_12
X_1145_ _0607_ cpu.immdec.gen_immdec_w_eq_1.imm19_12_20\[0\] _0610_ VGND VGND VPWR
+ VPWR _0611_ sky130_fd_sc_hd__mux2_1
XFILLER_0_1_55 VGND VGND VPWR VPWR sky130_fd_sc_hd__fill_1
X_1214_ _0180_ VGND VGND VPWR VPWR _0128_ sky130_fd_sc_hd__clkbuf_1
XFILLER_0_47_203 VPWR VGND VPWR VGND sky130_ef_sc_hd__decap_12
X_1076_ net86 net87 _0550_ VGND VGND VPWR VPWR _0558_ sky130_fd_sc_hd__mux2_1
X_0929_ cpu.gen_csr.csr.mie_mtie _0419_ cpu.gen_csr.csr.mstatus_mie net68 VGND VGND
+ VPWR VPWR _0483_ sky130_fd_sc_hd__nand4_1
XTAP_309 VGND VPWR sky130_fd_sc_hd__tapvpwrvgnd_1
XFILLER_0_21_125 VGND VGND VPWR VPWR sky130_fd_sc_hd__decap_8
XFILLER_0_32_66 VPWR VGND VPWR VGND sky130_ef_sc_hd__decap_12
XFILLER_0_32_11 VGND VGND VPWR VPWR sky130_fd_sc_hd__fill_1
XFILLER_0_29_225 VGND VGND VPWR VPWR sky130_fd_sc_hd__decap_6
XFILLER_0_52_272 VGND VGND VPWR VPWR sky130_fd_sc_hd__decap_4
X_0714_ net137 _0294_ cpu.ctrl.pc_plus_offset_cy_r VGND VGND VPWR VPWR _0296_ sky130_fd_sc_hd__a21oi_1
XFILLER_0_12_114 VGND VGND VPWR VPWR sky130_fd_sc_hd__fill_1
X_1059_ net78 net79 _0539_ VGND VGND VPWR VPWR _0549_ sky130_fd_sc_hd__mux2_1
X_1128_ _0599_ VGND VGND VPWR VPWR _0101_ sky130_fd_sc_hd__clkbuf_1
XFILLER_0_50_209 VGND VGND VPWR VPWR sky130_fd_sc_hd__decap_8
XFILLER_0_28_280 VGND VGND VPWR VPWR sky130_fd_sc_hd__decap_3
XFILLER_0_7_185 VPWR VGND VPWR VGND sky130_ef_sc_hd__decap_12
Xoutput69 net69 VGND VGND VPWR VPWR o_dbus_adr[10] sky130_fd_sc_hd__clkbuf_4
XFILLER_0_34_283 VGND VGND VPWR VPWR sky130_fd_sc_hd__fill_1
XFILLER_0_34_272 VGND VGND VPWR VPWR sky130_fd_sc_hd__fill_2
XTAP_139 VGND VPWR sky130_fd_sc_hd__tapvpwrvgnd_1
XTAP_128 VGND VPWR sky130_fd_sc_hd__tapvpwrvgnd_1
XTAP_106 VGND VPWR sky130_fd_sc_hd__tapvpwrvgnd_1
XTAP_117 VGND VPWR sky130_fd_sc_hd__tapvpwrvgnd_1
XPHY_0 VGND VGND VPWR VPWR sky130_fd_sc_hd__decap_3
XFILLER_0_27_99 VGND VGND VPWR VPWR sky130_fd_sc_hd__decap_4
XFILLER_0_17_239 VGND VGND VPWR VPWR sky130_fd_sc_hd__decap_6
XFILLER_0_40_286 VPWR VGND VPWR VGND sky130_ef_sc_hd__decap_12
XFILLER_0_40_242 VGND VGND VPWR VPWR sky130_fd_sc_hd__decap_6
XFILLER_0_4_188 VGND VGND VPWR VPWR sky130_fd_sc_hd__decap_8
XFILLER_0_23_209 VGND VGND VPWR VPWR sky130_fd_sc_hd__decap_8
XFILLER_0_7_3 VGND VGND VPWR VPWR sky130_fd_sc_hd__decap_4
X_1462_ clknet_4_14_0_clk _0124_ VGND VGND VPWR VPWR cpu.immdec.gen_immdec_w_eq_1.imm24_20\[1\]
+ sky130_fd_sc_hd__dfxtp_1
X_1393_ clknet_4_11_0_clk _0058_ VGND VGND VPWR VPWR net153 sky130_fd_sc_hd__dfxtp_1
XFILLER_0_9_203 VGND VGND VPWR VPWR sky130_fd_sc_hd__fill_2
XFILLER_0_9_225 VPWR VGND VPWR VGND sky130_ef_sc_hd__decap_12
XFILLER_0_0_191 VGND VGND VPWR VPWR sky130_fd_sc_hd__decap_4
XFILLER_0_13_275 VGND VGND VPWR VPWR sky130_fd_sc_hd__decap_4
XFILLER_0_13_297 VGND VGND VPWR VPWR sky130_fd_sc_hd__decap_4
XFILLER_0_51_304 VGND VGND VPWR VPWR sky130_fd_sc_hd__fill_2
XFILLER_0_48_150 VPWR VGND VPWR VGND sky130_ef_sc_hd__decap_12
XFILLER_0_46_109 VGND VGND VPWR VPWR sky130_fd_sc_hd__decap_8
XFILLER_0_24_12 VGND VGND VPWR VPWR sky130_fd_sc_hd__fill_1
X_0893_ cpu.immdec.gen_immdec_w_eq_1.imm11_7\[2\] cpu.immdec.gen_immdec_w_eq_1.imm11_7\[3\]
+ cpu.immdec.gen_immdec_w_eq_1.imm11_7\[4\] VGND VGND VPWR VPWR _0455_ sky130_fd_sc_hd__or3_1
X_0962_ cpu.gen_csr.csr.mcause3_0\[2\] _0507_ _0503_ VGND VGND VPWR VPWR _0508_ sky130_fd_sc_hd__mux2_1
X_1445_ clknet_4_12_0_clk _0107_ VGND VGND VPWR VPWR cpu.immdec.gen_immdec_w_eq_1.imm19_12_20\[0\]
+ sky130_fd_sc_hd__dfxtp_1
XFILLER_0_10_289 VPWR VGND VPWR VGND sky130_ef_sc_hd__decap_12
X_1376_ clknet_4_4_0_clk _0041_ VGND VGND VPWR VPWR net166 sky130_fd_sc_hd__dfxtp_2
XFILLER_0_45_142 VGND VGND VPWR VPWR sky130_fd_sc_hd__decap_6
XFILLER_0_36_164 VPWR VGND VPWR VGND sky130_ef_sc_hd__decap_12
X_1161_ _0621_ cpu.immdec.gen_immdec_w_eq_1.imm19_12_20\[5\] _0610_ VGND VGND VPWR
+ VPWR _0622_ sky130_fd_sc_hd__mux2_1
X_1230_ net136 net60 _0515_ VGND VGND VPWR VPWR _0187_ sky130_fd_sc_hd__mux2_1
XFILLER_0_35_55 VGND VGND VPWR VPWR sky130_fd_sc_hd__fill_1
X_1092_ _0311_ cpu.bufreg.data\[1\] cpu.bufreg.data\[0\] _0332_ VGND VGND VPWR VPWR
+ _0569_ sky130_fd_sc_hd__o211a_1
XFILLER_0_42_145 VGND VGND VPWR VPWR sky130_fd_sc_hd__decap_6
XFILLER_0_42_101 VPWR VGND VPWR VGND sky130_ef_sc_hd__decap_12
X_0945_ cpu.gen_csr.csr.mie_mtie _0394_ _0495_ VGND VGND VPWR VPWR _0496_ sky130_fd_sc_hd__mux2_1
XFILLER_0_2_253 VPWR VGND VPWR VGND sky130_ef_sc_hd__decap_12
X_0876_ _0309_ _0318_ _0439_ _0441_ _0299_ VGND VGND VPWR VPWR _0442_ sky130_fd_sc_hd__o221a_1
XFILLER_0_27_164 VGND VGND VPWR VPWR sky130_fd_sc_hd__decap_4
X_1428_ clknet_4_5_0_clk _0091_ VGND VGND VPWR VPWR net86 sky130_fd_sc_hd__dfxtp_1
X_1359_ clknet_4_7_0_clk _0025_ VGND VGND VPWR VPWR cpu.gen_csr.csr.mcause3_0\[0\]
+ sky130_fd_sc_hd__dfxtp_1
XFILLER_0_18_186 VGND VGND VPWR VPWR sky130_fd_sc_hd__decap_8
XFILLER_0_18_197 VGND VGND VPWR VPWR sky130_fd_sc_hd__decap_3
XFILLER_0_33_156 VPWR VGND VPWR VGND sky130_ef_sc_hd__decap_12
X_0730_ cpu.state.o_cnt\[2\] VGND VGND VPWR VPWR _0312_ sky130_fd_sc_hd__clkbuf_4
XFILLER_0_12_307 VGND VGND VPWR VPWR sky130_fd_sc_hd__fill_1
X_0661_ cpu.bne_or_bge cpu.decode.co_mem_word VGND VGND VPWR VPWR _0257_ sky130_fd_sc_hd__or2_1
XFILLER_0_24_101 VGND VGND VPWR VPWR sky130_fd_sc_hd__fill_1
XFILLER_0_46_21 VGND VGND VPWR VPWR sky130_fd_sc_hd__decap_6
X_1213_ cpu.decode.op26 net51 _0420_ VGND VGND VPWR VPWR _0180_ sky130_fd_sc_hd__mux2_1
XFILLER_0_46_65 VPWR VGND VPWR VGND sky130_ef_sc_hd__decap_12
X_1075_ _0557_ VGND VGND VPWR VPWR _0090_ sky130_fd_sc_hd__clkbuf_1
XFILLER_0_1_78 VGND VGND VPWR VPWR sky130_fd_sc_hd__decap_8
X_1144_ _0397_ _0609_ _0419_ VGND VGND VPWR VPWR _0610_ sky130_fd_sc_hd__a21oi_4
XFILLER_0_47_215 VGND VGND VPWR VPWR sky130_fd_sc_hd__decap_8
X_0928_ _0482_ VGND VGND VPWR VPWR _0018_ sky130_fd_sc_hd__clkbuf_1
XFILLER_0_30_137 VGND VGND VPWR VPWR sky130_fd_sc_hd__decap_3
XFILLER_0_15_167 VGND VGND VPWR VPWR sky130_fd_sc_hd__fill_1
X_0859_ cpu.alu.i_rs1 _0425_ VGND VGND VPWR VPWR _0427_ sky130_fd_sc_hd__nand2_1
XFILLER_0_16_46 VGND VGND VPWR VPWR sky130_fd_sc_hd__decap_6
XFILLER_0_37_281 VPWR VGND VPWR VGND sky130_ef_sc_hd__decap_12
XFILLER_0_32_78 VGND VGND VPWR VPWR sky130_fd_sc_hd__decap_6
XFILLER_0_12_159 VPWR VGND VPWR VGND sky130_ef_sc_hd__decap_12
X_0713_ net137 cpu.ctrl.pc_plus_offset_cy_r _0294_ VGND VGND VPWR VPWR _0295_ sky130_fd_sc_hd__and3_1
XFILLER_0_20_181 VGND VGND VPWR VPWR sky130_fd_sc_hd__decap_6
X_1058_ _0548_ VGND VGND VPWR VPWR _0082_ sky130_fd_sc_hd__clkbuf_1
X_1127_ net121 _0598_ _0574_ VGND VGND VPWR VPWR _0599_ sky130_fd_sc_hd__mux2_1
XFILLER_0_7_142 VGND VGND VPWR VPWR sky130_fd_sc_hd__decap_3
XFILLER_0_7_197 VPWR VGND VPWR VGND sky130_ef_sc_hd__decap_12
XFILLER_0_19_292 VGND VGND VPWR VPWR sky130_fd_sc_hd__fill_1
XTAP_129 VGND VPWR sky130_fd_sc_hd__tapvpwrvgnd_1
XTAP_107 VGND VPWR sky130_fd_sc_hd__tapvpwrvgnd_1
XTAP_118 VGND VPWR sky130_fd_sc_hd__tapvpwrvgnd_1
XFILLER_0_27_45 VGND VGND VPWR VPWR sky130_fd_sc_hd__decap_8
XPHY_1 VGND VGND VPWR VPWR sky130_fd_sc_hd__decap_3
XFILLER_0_17_218 VGND VGND VPWR VPWR sky130_fd_sc_hd__fill_1
XFILLER_0_40_298 VGND VGND VPWR VPWR sky130_fd_sc_hd__decap_6
XFILLER_0_7_55 VGND VGND VPWR VPWR sky130_fd_sc_hd__fill_1
X_1461_ clknet_4_14_0_clk _0123_ VGND VGND VPWR VPWR cpu.immdec.gen_immdec_w_eq_1.imm24_20\[0\]
+ sky130_fd_sc_hd__dfxtp_1
XFILLER_0_22_221 VGND VGND VPWR VPWR sky130_fd_sc_hd__fill_1
X_1392_ clknet_4_11_0_clk _0057_ VGND VGND VPWR VPWR net152 sky130_fd_sc_hd__dfxtp_1
XFILLER_0_9_237 VPWR VGND VPWR VGND sky130_ef_sc_hd__decap_12
XFILLER_0_0_181 VGND VGND VPWR VPWR sky130_fd_sc_hd__decap_4
XFILLER_0_48_162 VGND VGND VPWR VPWR sky130_fd_sc_hd__decap_4
X_0961_ cpu.gen_csr.csr.mcause3_0\[3\] _0272_ cpu.gen_csr.csr.o_new_irq _0290_ VGND
+ VGND VPWR VPWR _0507_ sky130_fd_sc_hd__a211o_1
X_0892_ net203 _0314_ _0452_ _0454_ VGND VGND VPWR VPWR _0010_ sky130_fd_sc_hd__a31o_1
X_1375_ clknet_4_1_0_clk _0040_ VGND VGND VPWR VPWR net165 sky130_fd_sc_hd__dfxtp_1
X_1444_ clknet_4_4_0_clk _0106_ VGND VGND VPWR VPWR cpu.immdec.gen_immdec_w_eq_1.imm31
+ sky130_fd_sc_hd__dfxtp_1
XFILLER_0_4_78 VGND VGND VPWR VPWR sky130_fd_sc_hd__decap_6
XFILLER_0_45_121 VGND VGND VPWR VPWR sky130_fd_sc_hd__fill_2
XFILLER_0_45_110 VGND VGND VPWR VPWR sky130_fd_sc_hd__fill_2
XFILLER_0_33_305 VGND VGND VPWR VPWR sky130_fd_sc_hd__decap_8
XTAP_290 VGND VPWR sky130_fd_sc_hd__tapvpwrvgnd_1
XFILLER_0_51_113 VGND VGND VPWR VPWR sky130_fd_sc_hd__fill_1
XFILLER_0_36_176 VGND VGND VPWR VPWR sky130_fd_sc_hd__decap_6
XFILLER_0_19_57 VGND VGND VPWR VPWR sky130_fd_sc_hd__decap_3
X_1160_ cpu.immdec.gen_immdec_w_eq_1.imm19_12_20\[6\] net41 _0614_ VGND VGND VPWR
+ VPWR _0621_ sky130_fd_sc_hd__mux2_1
X_1091_ _0566_ net18 _0567_ VGND VGND VPWR VPWR _0568_ sky130_fd_sc_hd__mux2_1
XFILLER_0_42_113 VPWR VGND VPWR VGND sky130_ef_sc_hd__decap_12
X_0944_ _0491_ _0358_ _0494_ VGND VGND VPWR VPWR _0495_ sky130_fd_sc_hd__nor3b_1
XFILLER_0_42_168 VGND VGND VPWR VPWR sky130_fd_sc_hd__fill_1
XFILLER_0_42_135 VGND VGND VPWR VPWR sky130_fd_sc_hd__decap_4
XFILLER_0_2_265 VPWR VGND VPWR VGND sky130_ef_sc_hd__decap_12
XFILLER_0_2_221 VPWR VGND VPWR VGND sky130_ef_sc_hd__decap_12
X_0875_ cpu.state.init_done _0300_ net193 VGND VGND VPWR VPWR _0441_ sky130_fd_sc_hd__and3_1
X_1427_ clknet_4_5_0_clk _0090_ VGND VGND VPWR VPWR net85 sky130_fd_sc_hd__dfxtp_1
X_1358_ clknet_4_6_0_clk _0024_ VGND VGND VPWR VPWR cpu.gen_csr.csr.mcause31 sky130_fd_sc_hd__dfxtp_1
X_1289_ _0226_ net10 _0590_ VGND VGND VPWR VPWR _0227_ sky130_fd_sc_hd__mux2_1
XFILLER_0_33_146 VGND VGND VPWR VPWR sky130_fd_sc_hd__fill_2
XFILLER_0_18_132 VGND VGND VPWR VPWR sky130_fd_sc_hd__decap_4
XFILLER_0_18_165 VGND VGND VPWR VPWR sky130_fd_sc_hd__fill_1
X_0660_ _0255_ VGND VGND VPWR VPWR _0256_ sky130_fd_sc_hd__inv_2
XFILLER_0_46_77 VGND VGND VPWR VPWR sky130_fd_sc_hd__decap_6
X_1212_ cpu.immdec.gen_immdec_w_eq_1.imm30_25\[0\] _0651_ _0652_ cpu.immdec.gen_immdec_w_eq_1.imm24_20\[4\]
+ _0179_ VGND VGND VPWR VPWR _0127_ sky130_fd_sc_hd__a221o_1
X_1074_ net85 net86 _0550_ VGND VGND VPWR VPWR _0557_ sky130_fd_sc_hd__mux2_1
X_1143_ _0288_ _0388_ _0300_ _0608_ VGND VGND VPWR VPWR _0609_ sky130_fd_sc_hd__a31o_1
X_0927_ rf_ram_if.wen1_r _0481_ _0252_ VGND VGND VPWR VPWR _0482_ sky130_fd_sc_hd__mux2_1
XFILLER_0_15_113 VGND VGND VPWR VPWR sky130_fd_sc_hd__decap_8
X_0858_ cpu.alu.add_cy_r _0423_ _0424_ _0425_ cpu.alu.i_rs1 VGND VGND VPWR VPWR _0426_
+ sky130_fd_sc_hd__o311a_1
X_0789_ net136 VGND VGND VPWR VPWR _0371_ sky130_fd_sc_hd__inv_2
XFILLER_0_38_216 VGND VGND VPWR VPWR sky130_fd_sc_hd__decap_8
XFILLER_0_16_69 VGND VGND VPWR VPWR sky130_fd_sc_hd__decap_4
XFILLER_0_37_293 VPWR VGND VPWR VGND sky130_ef_sc_hd__decap_12
XFILLER_0_32_46 VGND VGND VPWR VPWR sky130_fd_sc_hd__fill_2
XFILLER_0_29_249 VGND VGND VPWR VPWR sky130_fd_sc_hd__fill_2
XFILLER_0_52_296 VGND VGND VPWR VPWR sky130_fd_sc_hd__decap_4
X_0712_ _0289_ cpu.decode.opcode\[1\] _0291_ _0292_ _0293_ VGND VGND VPWR VPWR _0294_
+ sky130_fd_sc_hd__a221o_1
XFILLER_0_20_160 VGND VGND VPWR VPWR sky130_fd_sc_hd__fill_1
X_1126_ _0590_ net23 _0318_ _0597_ VGND VGND VPWR VPWR _0598_ sky130_fd_sc_hd__a22o_1
X_1057_ net77 net78 _0539_ VGND VGND VPWR VPWR _0548_ sky130_fd_sc_hd__mux2_1
XFILLER_0_7_110 VGND VGND VPWR VPWR sky130_fd_sc_hd__fill_2
XFILLER_0_43_263 VPWR VGND VPWR VGND sky130_ef_sc_hd__decap_12
XFILLER_0_43_252 VGND VGND VPWR VPWR sky130_fd_sc_hd__fill_2
XPHY_100 VGND VGND VPWR VPWR sky130_fd_sc_hd__decap_3
XFILLER_0_26_219 VGND VGND VPWR VPWR sky130_fd_sc_hd__decap_8
XTAP_108 VGND VPWR sky130_fd_sc_hd__tapvpwrvgnd_1
XTAP_119 VGND VPWR sky130_fd_sc_hd__tapvpwrvgnd_1
XFILLER_0_27_57 VGND VGND VPWR VPWR sky130_fd_sc_hd__decap_8
XPHY_2 VGND VGND VPWR VPWR sky130_fd_sc_hd__decap_3
Xclkbuf_0_clk clk VGND VGND VPWR VPWR clknet_0_clk sky130_fd_sc_hd__clkbuf_16
XFILLER_0_7_34 VPWR VGND VPWR VGND sky130_ef_sc_hd__decap_12
XFILLER_0_4_157 VPWR VGND VPWR VGND sky130_ef_sc_hd__decap_12
XFILLER_0_48_300 VGND VGND VPWR VPWR sky130_fd_sc_hd__decap_4
X_1109_ net119 _0565_ _0583_ VGND VGND VPWR VPWR _0584_ sky130_fd_sc_hd__o21ba_1
XFILLER_0_31_288 VPWR VGND VPWR VGND sky130_ef_sc_hd__decap_12
X_1391_ clknet_4_10_0_clk _0056_ VGND VGND VPWR VPWR net151 sky130_fd_sc_hd__dfxtp_1
X_1460_ clknet_4_11_0_clk _0122_ VGND VGND VPWR VPWR cpu.immdec.gen_immdec_w_eq_1.imm30_25\[5\]
+ sky130_fd_sc_hd__dfxtp_1
XFILLER_0_49_108 VGND VGND VPWR VPWR sky130_fd_sc_hd__decap_4
XFILLER_0_9_249 VPWR VGND VPWR VGND sky130_ef_sc_hd__decap_12
XFILLER_0_13_200 VGND VGND VPWR VPWR sky130_fd_sc_hd__fill_2
XFILLER_0_13_288 VGND VGND VPWR VPWR sky130_fd_sc_hd__fill_2
XFILLER_0_0_160 VGND VGND VPWR VPWR sky130_fd_sc_hd__fill_2
XFILLER_0_36_303 VGND VGND VPWR VPWR sky130_fd_sc_hd__decap_4
X_0960_ _0506_ VGND VGND VPWR VPWR _0026_ sky130_fd_sc_hd__clkbuf_1
XFILLER_0_40_24 VGND VGND VPWR VPWR sky130_fd_sc_hd__fill_1
XFILLER_0_24_36 VGND VGND VPWR VPWR sky130_fd_sc_hd__decap_8
XFILLER_0_27_303 VGND VGND VPWR VPWR sky130_fd_sc_hd__decap_8
XFILLER_0_49_55 VGND VGND VPWR VPWR sky130_fd_sc_hd__fill_1
X_0891_ _0314_ _0452_ _0453_ VGND VGND VPWR VPWR _0454_ sky130_fd_sc_hd__a21oi_1
X_1512_ clknet_4_6_0_clk _0174_ VGND VGND VPWR VPWR cpu.ctrl.i_jump sky130_fd_sc_hd__dfxtp_1
X_1443_ clknet_4_13_0_clk _0105_ VGND VGND VPWR VPWR cpu.gen_csr.csr.timer_irq_r sky130_fd_sc_hd__dfxtp_1
X_1374_ clknet_4_1_0_clk _0039_ VGND VGND VPWR VPWR net164 sky130_fd_sc_hd__dfxtp_1
XFILLER_0_5_241 VPWR VGND VPWR VGND sky130_ef_sc_hd__decap_12
XFILLER_0_14_80 VGND VGND VPWR VPWR sky130_fd_sc_hd__fill_1
XTAP_291 VGND VPWR sky130_fd_sc_hd__tapvpwrvgnd_1
XTAP_280 VGND VPWR sky130_fd_sc_hd__tapvpwrvgnd_1
XFILLER_0_51_169 VPWR VGND VPWR VGND sky130_ef_sc_hd__decap_12
XFILLER_0_19_36 VPWR VGND VPWR VGND sky130_ef_sc_hd__decap_12
XFILLER_0_19_69 VPWR VGND VPWR VGND sky130_ef_sc_hd__decap_12
X_1090_ net1 VGND VGND VPWR VPWR _0567_ sky130_fd_sc_hd__buf_2
XFILLER_0_42_125 VGND VGND VPWR VPWR sky130_fd_sc_hd__fill_1
X_0943_ _0492_ _0493_ _0357_ VGND VGND VPWR VPWR _0494_ sky130_fd_sc_hd__and3b_1
X_0874_ _0290_ _0307_ cpu.decode.opcode\[2\] _0439_ VGND VGND VPWR VPWR _0440_ sky130_fd_sc_hd__and4_1
XFILLER_0_27_111 VGND VGND VPWR VPWR sky130_fd_sc_hd__fill_1
XFILLER_0_27_177 VGND VGND VPWR VPWR sky130_fd_sc_hd__decap_8
XFILLER_0_30_309 VGND VGND VPWR VPWR sky130_fd_sc_hd__fill_1
XFILLER_0_2_277 VPWR VGND VPWR VGND sky130_ef_sc_hd__decap_12
XFILLER_0_2_233 VPWR VGND VPWR VGND sky130_ef_sc_hd__decap_12
X_1288_ net108 net109 _0211_ VGND VGND VPWR VPWR _0226_ sky130_fd_sc_hd__mux2_1
X_1357_ clknet_4_7_0_clk _0023_ VGND VGND VPWR VPWR cpu.gen_csr.csr.mstatus_mpie sky130_fd_sc_hd__dfxtp_1
X_1426_ clknet_4_5_0_clk _0089_ VGND VGND VPWR VPWR net84 sky130_fd_sc_hd__dfxtp_1
XFILLER_0_18_100 VPWR VGND VPWR VGND sky130_ef_sc_hd__decap_12
XFILLER_0_25_90 VGND VGND VPWR VPWR sky130_fd_sc_hd__decap_8
XFILLER_0_12_309 VGND VGND VPWR VPWR sky130_fd_sc_hd__fill_1
X_1211_ _0515_ net49 VGND VGND VPWR VPWR _0179_ sky130_fd_sc_hd__and2_1
X_1142_ cpu.decode.opcode\[1\] _0289_ _0388_ VGND VGND VPWR VPWR _0608_ sky130_fd_sc_hd__mux2_1
X_1073_ _0556_ VGND VGND VPWR VPWR _0089_ sky130_fd_sc_hd__clkbuf_1
XFILLER_0_1_25 VPWR VGND VPWR VGND sky130_ef_sc_hd__decap_12
X_0926_ _0263_ _0266_ _0397_ VGND VGND VPWR VPWR _0481_ sky130_fd_sc_hd__o21a_1
XFILLER_0_30_128 VGND VGND VPWR VPWR sky130_fd_sc_hd__fill_1
XFILLER_0_30_117 VGND VGND VPWR VPWR sky130_fd_sc_hd__fill_1
XFILLER_0_15_169 VGND VGND VPWR VPWR sky130_fd_sc_hd__fill_1
X_0857_ _0300_ cpu.bne_or_bge _0298_ VGND VGND VPWR VPWR _0425_ sky130_fd_sc_hd__o21ai_1
X_1409_ clknet_4_0_0_clk _0072_ VGND VGND VPWR VPWR net97 sky130_fd_sc_hd__dfxtp_1
X_0788_ _0313_ _0328_ _0330_ net136 VGND VGND VPWR VPWR _0370_ sky130_fd_sc_hd__a211o_2
XFILLER_0_52_253 VGND VGND VPWR VPWR sky130_fd_sc_hd__fill_2
X_0711_ cpu.decode.opcode\[0\] cpu.decode.opcode\[1\] cpu.decode.opcode\[2\] VGND
+ VGND VPWR VPWR _0293_ sky130_fd_sc_hd__nor3_1
XFILLER_0_12_139 VGND VGND VPWR VPWR sky130_fd_sc_hd__fill_1
XFILLER_0_20_172 VGND VGND VPWR VPWR sky130_fd_sc_hd__decap_4
X_1125_ _0565_ _0596_ _0567_ VGND VGND VPWR VPWR _0597_ sky130_fd_sc_hd__o21ba_1
X_1056_ _0547_ VGND VGND VPWR VPWR _0081_ sky130_fd_sc_hd__clkbuf_1
XFILLER_0_28_261 VGND VGND VPWR VPWR sky130_fd_sc_hd__decap_3
XFILLER_0_43_297 VGND VGND VPWR VPWR sky130_fd_sc_hd__fill_1
XFILLER_0_43_275 VGND VGND VPWR VPWR sky130_fd_sc_hd__decap_4
XFILLER_0_43_220 VGND VGND VPWR VPWR sky130_fd_sc_hd__decap_4
X_0909_ _0461_ _0466_ _0467_ VGND VGND VPWR VPWR _0468_ sky130_fd_sc_hd__and3_1
XPHY_101 VGND VGND VPWR VPWR sky130_fd_sc_hd__decap_3
XFILLER_0_34_253 VGND VGND VPWR VPWR sky130_fd_sc_hd__decap_4
XFILLER_0_26_209 VGND VGND VPWR VPWR sky130_fd_sc_hd__fill_1
XTAP_109 VGND VPWR sky130_fd_sc_hd__tapvpwrvgnd_1
XFILLER_0_43_57 VGND VGND VPWR VPWR sky130_fd_sc_hd__decap_3
XPHY_3 VGND VGND VPWR VPWR sky130_fd_sc_hd__decap_3
XFILLER_0_7_68 VGND VGND VPWR VPWR sky130_fd_sc_hd__fill_1
XFILLER_0_7_57 VGND VGND VPWR VPWR sky130_fd_sc_hd__decap_8
XFILLER_0_7_46 VGND VGND VPWR VPWR sky130_fd_sc_hd__fill_2
XFILLER_0_4_169 VGND VGND VPWR VPWR sky130_fd_sc_hd__fill_1
XFILLER_0_25_220 VGND VGND VPWR VPWR sky130_fd_sc_hd__decap_4
XFILLER_0_25_297 VPWR VGND VPWR VGND sky130_ef_sc_hd__decap_12
XFILLER_0_7_79 VPWR VGND VPWR VGND sky130_ef_sc_hd__decap_12
X_1108_ _0565_ _0581_ _0582_ _0567_ VGND VGND VPWR VPWR _0583_ sky130_fd_sc_hd__a31o_1
X_1039_ _0538_ VGND VGND VPWR VPWR _0073_ sky130_fd_sc_hd__clkbuf_1
XFILLER_0_31_267 VPWR VGND VPWR VGND sky130_ef_sc_hd__decap_12
XFILLER_0_31_245 VGND VGND VPWR VPWR sky130_fd_sc_hd__decap_3
XFILLER_0_31_223 VGND VGND VPWR VPWR sky130_fd_sc_hd__fill_1
X_1390_ clknet_4_10_0_clk _0055_ VGND VGND VPWR VPWR net150 sky130_fd_sc_hd__dfxtp_1
XFILLER_0_22_278 VGND VGND VPWR VPWR sky130_fd_sc_hd__fill_2
XFILLER_0_13_234 VPWR VGND VPWR VGND sky130_ef_sc_hd__decap_12
XFILLER_0_48_197 VPWR VGND VPWR VGND sky130_ef_sc_hd__decap_12
XFILLER_0_5_3 VGND VGND VPWR VPWR sky130_fd_sc_hd__decap_3
X_0890_ net67 _0402_ VGND VGND VPWR VPWR _0453_ sky130_fd_sc_hd__nor2_4
XFILLER_0_49_12 VPWR VGND VPWR VGND sky130_ef_sc_hd__decap_12
X_1442_ clknet_4_3_0_clk _0104_ VGND VGND VPWR VPWR cpu.alu.cmp_r sky130_fd_sc_hd__dfxtp_1
X_1511_ clknet_4_3_0_clk _0173_ VGND VGND VPWR VPWR cpu.state.init_done sky130_fd_sc_hd__dfxtp_1
X_1373_ clknet_4_4_0_clk _0038_ VGND VGND VPWR VPWR net163 sky130_fd_sc_hd__dfxtp_1
XFILLER_0_45_167 VGND VGND VPWR VPWR sky130_fd_sc_hd__fill_1
XFILLER_0_5_253 VPWR VGND VPWR VGND sky130_ef_sc_hd__decap_12
XTAP_292 VGND VPWR sky130_fd_sc_hd__tapvpwrvgnd_1
XTAP_281 VGND VPWR sky130_fd_sc_hd__tapvpwrvgnd_1
XTAP_270 VGND VPWR sky130_fd_sc_hd__tapvpwrvgnd_1
XFILLER_0_19_48 VGND VGND VPWR VPWR sky130_fd_sc_hd__decap_8
XFILLER_0_35_69 VPWR VGND VPWR VGND sky130_ef_sc_hd__decap_12
XFILLER_0_51_57 VPWR VGND VPWR VGND sky130_ef_sc_hd__decap_12
X_0942_ _0332_ VGND VGND VPWR VPWR _0493_ sky130_fd_sc_hd__inv_2
X_0873_ _0401_ _0314_ VGND VGND VPWR VPWR _0439_ sky130_fd_sc_hd__nor2_1
XFILLER_0_48_6 VPWR VGND VPWR VGND sky130_ef_sc_hd__decap_12
X_1425_ clknet_4_5_0_clk _0088_ VGND VGND VPWR VPWR net83 sky130_fd_sc_hd__dfxtp_2
XFILLER_0_2_289 VGND VGND VPWR VPWR sky130_fd_sc_hd__decap_8
XFILLER_0_2_245 VGND VGND VPWR VPWR sky130_fd_sc_hd__decap_6
X_1287_ _0225_ VGND VGND VPWR VPWR _0156_ sky130_fd_sc_hd__clkbuf_1
X_1356_ clknet_4_12_0_clk _0022_ VGND VGND VPWR VPWR cpu.gen_csr.csr.mie_mtie sky130_fd_sc_hd__dfxtp_1
XFILLER_0_18_112 VGND VGND VPWR VPWR sky130_fd_sc_hd__fill_1
XFILLER_0_41_90 VGND VGND VPWR VPWR sky130_fd_sc_hd__fill_2
XFILLER_0_49_281 VPWR VGND VPWR VGND sky130_ef_sc_hd__decap_12
XFILLER_0_21_38 VGND VGND VPWR VPWR sky130_fd_sc_hd__fill_1
XFILLER_0_32_192 VGND VGND VPWR VPWR sky130_fd_sc_hd__decap_4
X_1210_ _0178_ VGND VGND VPWR VPWR _0126_ sky130_fd_sc_hd__clkbuf_1
X_1072_ net84 net85 _0550_ VGND VGND VPWR VPWR _0556_ sky130_fd_sc_hd__mux2_1
X_1141_ _0447_ cpu.immdec.gen_immdec_w_eq_1.imm19_12_20\[1\] _0606_ VGND VGND VPWR
+ VPWR _0607_ sky130_fd_sc_hd__a21o_1
XFILLER_0_1_37 VPWR VGND VPWR VGND sky130_ef_sc_hd__decap_12
X_0787_ _0307_ _0260_ _0350_ _0368_ VGND VGND VPWR VPWR _0369_ sky130_fd_sc_hd__a31o_1
XFILLER_0_15_148 VGND VGND VPWR VPWR sky130_fd_sc_hd__fill_1
X_0856_ _0370_ _0372_ _0382_ VGND VGND VPWR VPWR _0424_ sky130_fd_sc_hd__a21boi_1
X_0925_ _0480_ VGND VGND VPWR VPWR _0017_ sky130_fd_sc_hd__clkbuf_1
X_1408_ clknet_4_0_0_clk _0071_ VGND VGND VPWR VPWR net96 sky130_fd_sc_hd__dfxtp_1
X_1339_ clknet_4_1_0_clk _0007_ VGND VGND VPWR VPWR net170 sky130_fd_sc_hd__dfxtp_2
XFILLER_0_46_240 VPWR VGND VPWR VGND sky130_ef_sc_hd__decap_12
XFILLER_0_37_240 VGND VGND VPWR VPWR sky130_fd_sc_hd__fill_1
XFILLER_0_37_273 VGND VGND VPWR VPWR sky130_fd_sc_hd__decap_6
X_0710_ cpu.decode.opcode\[2\] cpu.decode.co_ebreak _0290_ VGND VGND VPWR VPWR _0292_
+ sky130_fd_sc_hd__a21o_1
XFILLER_0_4_307 VGND VGND VPWR VPWR sky130_fd_sc_hd__fill_1
XFILLER_0_20_151 VGND VGND VPWR VPWR sky130_fd_sc_hd__decap_6
X_1055_ net76 net77 _0539_ VGND VGND VPWR VPWR _0547_ sky130_fd_sc_hd__mux2_1
X_1124_ _0299_ _0494_ VGND VGND VPWR VPWR _0596_ sky130_fd_sc_hd__nand2_1
XFILLER_0_28_251 VGND VGND VPWR VPWR sky130_fd_sc_hd__fill_1
X_0839_ _0310_ cpu.state.cnt_r\[0\] cpu.state.cnt_r\[1\] cpu.state.cnt_r\[2\] VGND
+ VGND VPWR VPWR _0411_ sky130_fd_sc_hd__nor4_1
X_0908_ rf_ram_if.rtrig0 net171 net170 net172 VGND VGND VPWR VPWR _0467_ sky130_fd_sc_hd__a31o_1
XPHY_102 VGND VGND VPWR VPWR sky130_fd_sc_hd__decap_3
XFILLER_0_43_69 VGND VGND VPWR VPWR sky130_fd_sc_hd__decap_4
XFILLER_0_4_115 VGND VGND VPWR VPWR sky130_fd_sc_hd__fill_1
XPHY_4 VGND VGND VPWR VPWR sky130_fd_sc_hd__decap_3
XFILLER_0_4_137 VGND VGND VPWR VPWR sky130_fd_sc_hd__decap_3
XFILLER_0_25_254 VPWR VGND VPWR VGND sky130_ef_sc_hd__decap_12
X_1038_ net98 net69 _0342_ VGND VGND VPWR VPWR _0538_ sky130_fd_sc_hd__mux2_1
X_1107_ net116 net117 net118 VGND VGND VPWR VPWR _0582_ sky130_fd_sc_hd__o21ai_1
XFILLER_0_31_279 VGND VGND VPWR VPWR sky130_fd_sc_hd__fill_1
XFILLER_0_13_17 VGND VGND VPWR VPWR sky130_fd_sc_hd__fill_2
XFILLER_0_1_107 VGND VGND VPWR VPWR sky130_fd_sc_hd__decap_4
XFILLER_0_45_305 VGND VGND VPWR VPWR sky130_fd_sc_hd__decap_3
XFILLER_0_0_195 VGND VGND VPWR VPWR sky130_fd_sc_hd__fill_1
XFILLER_0_13_246 VPWR VGND VPWR VGND sky130_ef_sc_hd__decap_12
XFILLER_0_13_279 VGND VGND VPWR VPWR sky130_fd_sc_hd__fill_1
XFILLER_0_48_110 VGND VGND VPWR VPWR sky130_fd_sc_hd__fill_2
XFILLER_0_8_251 VGND VGND VPWR VPWR sky130_fd_sc_hd__fill_1
XFILLER_0_39_154 VGND VGND VPWR VPWR sky130_fd_sc_hd__fill_1
XFILLER_0_49_57 VPWR VGND VPWR VGND sky130_ef_sc_hd__decap_12
XFILLER_0_49_35 VPWR VGND VPWR VGND sky130_ef_sc_hd__decap_12
XFILLER_0_49_24 VGND VGND VPWR VPWR sky130_fd_sc_hd__decap_8
X_1510_ clknet_4_5_0_clk _0172_ VGND VGND VPWR VPWR cpu.state.cnt_r\[3\] sky130_fd_sc_hd__dfxtp_1
XFILLER_0_10_216 VGND VGND VPWR VPWR sky130_fd_sc_hd__decap_8
X_1441_ clknet_4_3_0_clk _0002_ VGND VGND VPWR VPWR cpu.bufreg.c_r sky130_fd_sc_hd__dfxtp_1
X_1372_ clknet_4_4_0_clk _0037_ VGND VGND VPWR VPWR net162 sky130_fd_sc_hd__dfxtp_1
XFILLER_0_45_113 VGND VGND VPWR VPWR sky130_fd_sc_hd__decap_8
XFILLER_0_45_102 VGND VGND VPWR VPWR sky130_fd_sc_hd__decap_8
XFILLER_0_5_265 VPWR VGND VPWR VGND sky130_ef_sc_hd__decap_12
XTAP_293 VGND VPWR sky130_fd_sc_hd__tapvpwrvgnd_1
XTAP_282 VGND VPWR sky130_fd_sc_hd__tapvpwrvgnd_1
XTAP_271 VGND VPWR sky130_fd_sc_hd__tapvpwrvgnd_1
XTAP_260 VGND VPWR sky130_fd_sc_hd__tapvpwrvgnd_1
XFILLER_0_51_69 VPWR VGND VPWR VGND sky130_ef_sc_hd__decap_12
X_0941_ _0310_ _0312_ VGND VGND VPWR VPWR _0492_ sky130_fd_sc_hd__nand2_1
XFILLER_0_27_113 VPWR VGND VPWR VGND sky130_ef_sc_hd__decap_12
X_0872_ _0438_ VGND VGND VPWR VPWR _0006_ sky130_fd_sc_hd__clkbuf_1
X_1424_ clknet_4_7_0_clk _0087_ VGND VGND VPWR VPWR net82 sky130_fd_sc_hd__dfxtp_1
X_1355_ clknet_4_12_0_clk _0021_ VGND VGND VPWR VPWR cpu.gen_csr.csr.mstatus_mie sky130_fd_sc_hd__dfxtp_1
X_1286_ _0224_ net9 _0590_ VGND VGND VPWR VPWR _0225_ sky130_fd_sc_hd__mux2_1
XFILLER_0_18_157 VGND VGND VPWR VPWR sky130_fd_sc_hd__decap_8
XFILLER_0_33_138 VGND VGND VPWR VPWR sky130_fd_sc_hd__fill_1
XFILLER_0_49_293 VGND VGND VPWR VPWR sky130_fd_sc_hd__decap_8
XFILLER_0_24_105 VPWR VGND VPWR VGND sky130_ef_sc_hd__decap_12
X_1071_ _0555_ VGND VGND VPWR VPWR _0088_ sky130_fd_sc_hd__clkbuf_1
X_1140_ net34 net45 VGND VGND VPWR VPWR _0606_ sky130_fd_sc_hd__and2_1
XFILLER_0_1_49 VGND VGND VPWR VPWR sky130_fd_sc_hd__decap_6
XFILLER_0_7_305 VGND VGND VPWR VPWR sky130_fd_sc_hd__decap_6
X_0924_ cpu.bufreg.data\[1\] _0479_ _0475_ VGND VGND VPWR VPWR _0480_ sky130_fd_sc_hd__mux2_1
X_0786_ _0288_ _0289_ _0356_ _0367_ VGND VGND VPWR VPWR _0368_ sky130_fd_sc_hd__a31o_1
X_0855_ _0382_ _0372_ _0370_ VGND VGND VPWR VPWR _0423_ sky130_fd_sc_hd__and3b_1
X_1407_ clknet_4_0_0_clk _0070_ VGND VGND VPWR VPWR net95 sky130_fd_sc_hd__dfxtp_1
X_1338_ clknet_4_11_0_clk _0006_ VGND VGND VPWR VPWR rf_ram_if.rdata0\[1\] sky130_fd_sc_hd__dfxtp_1
X_1269_ _0213_ VGND VGND VPWR VPWR _0150_ sky130_fd_sc_hd__clkbuf_1
XFILLER_0_37_230 VGND VGND VPWR VPWR sky130_fd_sc_hd__decap_3
XFILLER_0_32_38 VGND VGND VPWR VPWR sky130_fd_sc_hd__decap_8
XFILLER_0_12_108 VGND VGND VPWR VPWR sky130_fd_sc_hd__decap_6
XFILLER_0_20_141 VGND VGND VPWR VPWR sky130_fd_sc_hd__decap_3
X_1054_ _0546_ VGND VGND VPWR VPWR _0080_ sky130_fd_sc_hd__clkbuf_1
X_1123_ _0595_ VGND VGND VPWR VPWR _0100_ sky130_fd_sc_hd__clkbuf_1
XFILLER_0_25_9 VGND VGND VPWR VPWR sky130_fd_sc_hd__decap_4
XFILLER_0_43_244 VGND VGND VPWR VPWR sky130_fd_sc_hd__decap_8
XFILLER_0_43_200 VGND VGND VPWR VPWR sky130_fd_sc_hd__fill_1
XFILLER_0_7_102 VGND VGND VPWR VPWR sky130_fd_sc_hd__decap_8
X_0907_ _0418_ _0445_ VGND VGND VPWR VPWR _0466_ sky130_fd_sc_hd__or2_1
XFILLER_0_22_82 VGND VGND VPWR VPWR sky130_fd_sc_hd__fill_2
X_0769_ net137 cpu.ctrl.pc_plus_4_cy_r VGND VGND VPWR VPWR _0351_ sky130_fd_sc_hd__and2_1
XFILLER_0_11_185 VGND VGND VPWR VPWR sky130_fd_sc_hd__fill_2
X_0838_ _0404_ _0410_ _0342_ VGND VGND VPWR VPWR _0002_ sky130_fd_sc_hd__o21a_1
XPHY_103 VGND VGND VPWR VPWR sky130_fd_sc_hd__decap_3
XFILLER_0_34_211 VPWR VGND VPWR VGND sky130_ef_sc_hd__decap_12
XFILLER_0_27_27 VGND VGND VPWR VPWR sky130_fd_sc_hd__fill_1
XFILLER_0_43_37 VGND VGND VPWR VPWR sky130_fd_sc_hd__fill_2
XFILLER_0_43_15 VPWR VGND VPWR VGND sky130_ef_sc_hd__decap_12
XPHY_5 VGND VGND VPWR VPWR sky130_fd_sc_hd__decap_3
XFILLER_0_25_200 VGND VGND VPWR VPWR sky130_fd_sc_hd__fill_1
XFILLER_0_25_266 VGND VGND VPWR VPWR sky130_fd_sc_hd__fill_2
X_1106_ net118 net116 net117 VGND VGND VPWR VPWR _0581_ sky130_fd_sc_hd__or3_1
X_1037_ _0537_ VGND VGND VPWR VPWR _0072_ sky130_fd_sc_hd__clkbuf_1
XFILLER_0_16_288 VGND VGND VPWR VPWR sky130_fd_sc_hd__decap_4
XFILLER_0_9_208 VPWR VGND VPWR VGND sky130_ef_sc_hd__decap_12
XFILLER_0_13_258 VGND VGND VPWR VPWR sky130_fd_sc_hd__fill_1
XFILLER_0_0_141 VGND VGND VPWR VPWR sky130_fd_sc_hd__fill_2
XFILLER_0_0_174 VGND VGND VPWR VPWR sky130_fd_sc_hd__decap_4
XFILLER_0_21_3 VGND VGND VPWR VPWR sky130_fd_sc_hd__fill_2
XFILLER_0_8_80 VGND VGND VPWR VPWR sky130_fd_sc_hd__decap_4
XFILLER_0_39_166 VGND VGND VPWR VPWR sky130_fd_sc_hd__fill_2
XFILLER_0_42_309 VGND VGND VPWR VPWR sky130_fd_sc_hd__decap_4
XFILLER_0_40_49 VPWR VGND VPWR VGND sky130_ef_sc_hd__decap_12
XFILLER_0_49_69 VPWR VGND VPWR VGND sky130_ef_sc_hd__decap_12
XFILLER_0_49_47 VGND VGND VPWR VPWR sky130_fd_sc_hd__decap_8
X_1371_ clknet_4_4_0_clk _0036_ VGND VGND VPWR VPWR net159 sky130_fd_sc_hd__dfxtp_2
XFILLER_0_4_27 VGND VGND VPWR VPWR sky130_fd_sc_hd__fill_1
X_1440_ clknet_4_2_0_clk _0103_ VGND VGND VPWR VPWR net124 sky130_fd_sc_hd__dfxtp_1
XFILLER_0_45_169 VGND VGND VPWR VPWR sky130_fd_sc_hd__decap_4
XFILLER_0_5_211 VGND VGND VPWR VPWR sky130_fd_sc_hd__decap_8
XFILLER_0_14_72 VGND VGND VPWR VPWR sky130_fd_sc_hd__decap_8
XFILLER_0_5_277 VGND VGND VPWR VPWR sky130_fd_sc_hd__decap_3
XFILLER_0_39_80 VGND VGND VPWR VPWR sky130_fd_sc_hd__decap_6
XTAP_294 VGND VPWR sky130_fd_sc_hd__tapvpwrvgnd_1
XTAP_283 VGND VPWR sky130_fd_sc_hd__tapvpwrvgnd_1
XTAP_272 VGND VPWR sky130_fd_sc_hd__tapvpwrvgnd_1
XTAP_250 VGND VPWR sky130_fd_sc_hd__tapvpwrvgnd_1
XTAP_261 VGND VPWR sky130_fd_sc_hd__tapvpwrvgnd_1
XFILLER_0_51_117 VPWR VGND VPWR VGND sky130_ef_sc_hd__decap_12
XFILLER_0_44_180 VPWR VGND VPWR VGND sky130_ef_sc_hd__decap_12
XFILLER_0_24_309 VGND VGND VPWR VPWR sky130_fd_sc_hd__fill_2
XFILLER_0_19_28 VGND VGND VPWR VPWR sky130_fd_sc_hd__fill_1
XFILLER_0_35_38 VGND VGND VPWR VPWR sky130_fd_sc_hd__fill_1
XFILLER_0_51_15 VGND VGND VPWR VPWR sky130_fd_sc_hd__fill_2
X_0940_ cpu.decode.op22 VGND VGND VPWR VPWR _0491_ sky130_fd_sc_hd__inv_2
XFILLER_0_27_103 VGND VGND VPWR VPWR sky130_fd_sc_hd__fill_1
XFILLER_0_27_125 VGND VGND VPWR VPWR sky130_fd_sc_hd__fill_1
XFILLER_0_27_147 VGND VGND VPWR VPWR sky130_fd_sc_hd__decap_4
XFILLER_0_42_139 VGND VGND VPWR VPWR sky130_fd_sc_hd__fill_1
X_0871_ _0276_ net66 VGND VGND VPWR VPWR _0438_ sky130_fd_sc_hd__and2_1
X_1285_ net107 net108 _0211_ VGND VGND VPWR VPWR _0224_ sky130_fd_sc_hd__mux2_1
X_1423_ clknet_4_5_0_clk _0086_ VGND VGND VPWR VPWR net81 sky130_fd_sc_hd__dfxtp_1
X_1354_ clknet_4_10_0_clk _0020_ VGND VGND VPWR VPWR cpu.bufreg.i_sh_signed sky130_fd_sc_hd__dfxtp_1
XFILLER_0_18_136 VGND VGND VPWR VPWR sky130_fd_sc_hd__fill_1
XFILLER_0_49_261 VPWR VGND VPWR VGND sky130_ef_sc_hd__decap_12
XFILLER_0_24_117 VGND VGND VPWR VPWR sky130_fd_sc_hd__decap_4
XFILLER_0_24_128 VGND VGND VPWR VPWR sky130_fd_sc_hd__fill_2
X_1070_ net83 net84 _0550_ VGND VGND VPWR VPWR _0555_ sky130_fd_sc_hd__mux2_1
X_0923_ net89 _0401_ _0478_ VGND VGND VPWR VPWR _0479_ sky130_fd_sc_hd__a21o_1
X_0854_ cpu.alu.cmp_r _0338_ _0309_ _0316_ VGND VGND VPWR VPWR _0422_ sky130_fd_sc_hd__o211ai_1
X_0785_ _0357_ _0359_ _0361_ _0366_ VGND VGND VPWR VPWR _0367_ sky130_fd_sc_hd__a31o_1
XFILLER_0_30_109 VGND VGND VPWR VPWR sky130_fd_sc_hd__decap_8
XFILLER_0_23_161 VGND VGND VPWR VPWR sky130_fd_sc_hd__fill_2
X_1268_ _0212_ net3 _0203_ VGND VGND VPWR VPWR _0213_ sky130_fd_sc_hd__mux2_1
X_1337_ clknet_4_4_0_clk cpu.o_wdata0 VGND VGND VPWR VPWR rf_ram_if.wdata0_r\[1\]
+ sky130_fd_sc_hd__dfxtp_1
X_1406_ clknet_4_0_0_clk _0069_ VGND VGND VPWR VPWR net94 sky130_fd_sc_hd__dfxtp_1
X_1199_ net202 _0636_ _0648_ _0649_ VGND VGND VPWR VPWR _0122_ sky130_fd_sc_hd__o22a_1
XFILLER_0_46_253 VPWR VGND VPWR VGND sky130_ef_sc_hd__decap_12
XFILLER_0_21_109 VGND VGND VPWR VPWR sky130_fd_sc_hd__decap_3
XFILLER_0_16_29 VGND VGND VPWR VPWR sky130_fd_sc_hd__fill_1
XFILLER_0_52_223 VGND VGND VPWR VPWR sky130_fd_sc_hd__fill_1
XFILLER_0_52_212 VGND VGND VPWR VPWR sky130_fd_sc_hd__fill_1
XFILLER_0_4_309 VGND VGND VPWR VPWR sky130_fd_sc_hd__fill_1
XFILLER_0_52_289 VGND VGND VPWR VPWR sky130_fd_sc_hd__fill_1
X_1122_ net120 _0594_ _0574_ VGND VGND VPWR VPWR _0595_ sky130_fd_sc_hd__mux2_1
XFILLER_0_18_9 VPWR VGND VPWR VGND sky130_ef_sc_hd__decap_12
X_1053_ net75 net76 _0539_ VGND VGND VPWR VPWR _0546_ sky130_fd_sc_hd__mux2_1
XFILLER_0_28_253 VGND VGND VPWR VPWR sky130_fd_sc_hd__decap_8
X_0906_ _0465_ VGND VGND VPWR VPWR _0013_ sky130_fd_sc_hd__clkbuf_1
X_0837_ _0409_ VGND VGND VPWR VPWR _0410_ sky130_fd_sc_hd__inv_2
X_0699_ _0284_ VGND VGND VPWR VPWR net187 sky130_fd_sc_hd__clkbuf_1
XFILLER_0_11_164 VGND VGND VPWR VPWR sky130_fd_sc_hd__fill_1
X_0768_ _0300_ _0347_ _0349_ VGND VGND VPWR VPWR _0350_ sky130_fd_sc_hd__o21ai_1
XPHY_104 VGND VGND VPWR VPWR sky130_fd_sc_hd__decap_3
XFILLER_0_34_223 VGND VGND VPWR VPWR sky130_fd_sc_hd__fill_2
XFILLER_0_43_27 VGND VGND VPWR VPWR sky130_fd_sc_hd__fill_1
XPHY_6 VGND VGND VPWR VPWR sky130_fd_sc_hd__decap_3
XFILLER_0_7_16 VGND VGND VPWR VPWR sky130_fd_sc_hd__fill_1
XFILLER_0_40_248 VGND VGND VPWR VPWR sky130_fd_sc_hd__fill_1
X_1105_ _0580_ VGND VGND VPWR VPWR _0097_ sky130_fd_sc_hd__clkbuf_1
XFILLER_0_48_304 VGND VGND VPWR VPWR sky130_fd_sc_hd__fill_1
X_1036_ net97 net98 _0342_ VGND VGND VPWR VPWR _0537_ sky130_fd_sc_hd__mux2_1
XFILLER_0_31_237 VGND VGND VPWR VPWR sky130_fd_sc_hd__decap_8
XFILLER_0_16_278 VGND VGND VPWR VPWR sky130_fd_sc_hd__decap_3
XFILLER_0_38_27 VGND VGND VPWR VPWR sky130_fd_sc_hd__fill_1
XFILLER_0_28_71 VPWR VGND VPWR VGND sky130_ef_sc_hd__decap_12
XFILLER_0_21_292 VGND VGND VPWR VPWR sky130_fd_sc_hd__decap_6
XFILLER_0_44_81 VGND VGND VPWR VPWR sky130_fd_sc_hd__decap_3
X_1019_ net160 _0453_ _0522_ net161 VGND VGND VPWR VPWR _0064_ sky130_fd_sc_hd__a22o_1
XFILLER_0_36_307 VGND VGND VPWR VPWR sky130_fd_sc_hd__fill_1
XFILLER_0_8_253 VPWR VGND VPWR VGND sky130_ef_sc_hd__decap_12
X_1370_ clknet_4_4_0_clk _0035_ VGND VGND VPWR VPWR net148 sky130_fd_sc_hd__dfxtp_2
XFILLER_0_30_83 VGND VGND VPWR VPWR sky130_fd_sc_hd__fill_1
XTAP_295 VGND VPWR sky130_fd_sc_hd__tapvpwrvgnd_1
XTAP_284 VGND VPWR sky130_fd_sc_hd__tapvpwrvgnd_1
XTAP_273 VGND VPWR sky130_fd_sc_hd__tapvpwrvgnd_1
X_1499_ clknet_4_8_0_clk _0161_ VGND VGND VPWR VPWR net113 sky130_fd_sc_hd__dfxtp_1
XTAP_240 VGND VPWR sky130_fd_sc_hd__tapvpwrvgnd_1
XTAP_251 VGND VPWR sky130_fd_sc_hd__tapvpwrvgnd_1
XTAP_262 VGND VPWR sky130_fd_sc_hd__tapvpwrvgnd_1
XFILLER_0_51_129 VPWR VGND VPWR VGND sky130_ef_sc_hd__decap_12
XFILLER_0_44_192 VGND VGND VPWR VPWR sky130_fd_sc_hd__decap_4
X_0870_ _0420_ _0437_ _0415_ VGND VGND VPWR VPWR _0005_ sky130_fd_sc_hd__o21ba_1
XFILLER_0_27_159 VGND VGND VPWR VPWR sky130_fd_sc_hd__fill_1
XFILLER_0_50_195 VGND VGND VPWR VPWR sky130_fd_sc_hd__fill_1
X_1422_ clknet_4_5_0_clk _0085_ VGND VGND VPWR VPWR net80 sky130_fd_sc_hd__dfxtp_1
X_1284_ _0223_ VGND VGND VPWR VPWR _0155_ sky130_fd_sc_hd__clkbuf_1
X_1353_ clknet_4_6_0_clk _0019_ VGND VGND VPWR VPWR cpu.gen_csr.csr.o_new_irq sky130_fd_sc_hd__dfxtp_2
X_0999_ net140 _0524_ _0525_ net141 VGND VGND VPWR VPWR _0046_ sky130_fd_sc_hd__a22o_1
XFILLER_0_1_281 VGND VGND VPWR VPWR sky130_fd_sc_hd__decap_8
XFILLER_0_49_273 VGND VGND VPWR VPWR sky130_fd_sc_hd__decap_6
XFILLER_0_32_173 VGND VGND VPWR VPWR sky130_fd_sc_hd__decap_3
XFILLER_0_46_27 VGND VGND VPWR VPWR sky130_fd_sc_hd__fill_1
X_0922_ _0401_ _0410_ _0477_ VGND VGND VPWR VPWR _0478_ sky130_fd_sc_hd__nor3_1
X_0853_ _0388_ _0413_ VGND VGND VPWR VPWR _0421_ sky130_fd_sc_hd__nor2_1
X_0784_ _0322_ _0362_ _0364_ _0365_ _0263_ VGND VGND VPWR VPWR _0366_ sky130_fd_sc_hd__a32o_1
X_1405_ clknet_4_0_0_clk _0068_ VGND VGND VPWR VPWR net93 sky130_fd_sc_hd__dfxtp_2
XFILLER_0_23_184 VGND VGND VPWR VPWR sky130_fd_sc_hd__decap_4
X_1267_ net101 net102 _0211_ VGND VGND VPWR VPWR _0212_ sky130_fd_sc_hd__mux2_1
X_1336_ clknet_4_4_0_clk net199 VGND VGND VPWR VPWR rf_ram_if.wdata0_r\[0\] sky130_fd_sc_hd__dfxtp_1
Xinput1 i_dbus_ack VGND VGND VPWR VPWR net1 sky130_fd_sc_hd__buf_1
X_1198_ _0420_ net56 _0636_ VGND VGND VPWR VPWR _0649_ sky130_fd_sc_hd__a21bo_1
XFILLER_0_46_276 VPWR VGND VPWR VGND sky130_ef_sc_hd__decap_12
XFILLER_0_46_265 VGND VGND VPWR VPWR sky130_fd_sc_hd__fill_2
XFILLER_0_14_195 VGND VGND VPWR VPWR sky130_fd_sc_hd__fill_1
XFILLER_0_52_268 VGND VGND VPWR VPWR sky130_fd_sc_hd__fill_1
XFILLER_0_52_279 VGND VGND VPWR VPWR sky130_fd_sc_hd__fill_1
XFILLER_0_20_121 VPWR VGND VPWR VGND sky130_ef_sc_hd__decap_12
X_1121_ _0590_ net22 _0592_ _0593_ VGND VGND VPWR VPWR _0594_ sky130_fd_sc_hd__a22o_1
X_1052_ _0545_ VGND VGND VPWR VPWR _0079_ sky130_fd_sc_hd__clkbuf_1
XFILLER_0_43_279 VGND VGND VPWR VPWR sky130_fd_sc_hd__fill_1
X_0905_ _0461_ _0463_ _0464_ VGND VGND VPWR VPWR _0465_ sky130_fd_sc_hd__and3_1
X_0767_ _0298_ _0346_ _0348_ VGND VGND VPWR VPWR _0349_ sky130_fd_sc_hd__o21ai_1
X_0836_ cpu.decode.opcode\[2\] _0331_ _0406_ _0408_ VGND VGND VPWR VPWR _0409_ sky130_fd_sc_hd__or4_1
X_0698_ cpu.immdec.gen_immdec_w_eq_1.imm11_7\[3\] _0280_ VGND VGND VPWR VPWR _0284_
+ sky130_fd_sc_hd__and2_1
XFILLER_0_47_81 VGND VGND VPWR VPWR sky130_fd_sc_hd__fill_1
XPHY_105 VGND VGND VPWR VPWR sky130_fd_sc_hd__decap_3
X_1319_ _0310_ _0244_ rf_ram_if.rgnt VGND VGND VPWR VPWR _0245_ sky130_fd_sc_hd__a21oi_1
XFILLER_0_19_276 VGND VGND VPWR VPWR sky130_fd_sc_hd__decap_4
XFILLER_0_6_181 VGND VGND VPWR VPWR sky130_fd_sc_hd__decap_3
Xoutput190 net190 VGND VGND VPWR VPWR o_wdata[0] sky130_fd_sc_hd__clkbuf_4
XPHY_7 VGND VGND VPWR VPWR sky130_fd_sc_hd__decap_3
XFILLER_0_0_313 VGND VGND VPWR VPWR sky130_fd_sc_hd__fill_1
X_1104_ _0578_ net19 _0579_ VGND VGND VPWR VPWR _0580_ sky130_fd_sc_hd__mux2_1
X_1035_ _0536_ VGND VGND VPWR VPWR _0071_ sky130_fd_sc_hd__clkbuf_1
XFILLER_0_31_205 VGND VGND VPWR VPWR sky130_fd_sc_hd__decap_4
X_0819_ _0398_ VGND VGND VPWR VPWR _0001_ sky130_fd_sc_hd__clkbuf_1
XFILLER_0_24_290 VGND VGND VPWR VPWR sky130_fd_sc_hd__fill_2
XFILLER_0_22_249 VGND VGND VPWR VPWR sky130_fd_sc_hd__decap_3
XFILLER_0_30_282 VGND VGND VPWR VPWR sky130_fd_sc_hd__fill_2
XTAP_400 VGND VPWR sky130_fd_sc_hd__tapvpwrvgnd_1
XFILLER_0_0_154 VGND VGND VPWR VPWR sky130_fd_sc_hd__decap_3
XFILLER_0_21_260 VGND VGND VPWR VPWR sky130_fd_sc_hd__fill_1
XFILLER_0_28_83 VGND VGND VPWR VPWR sky130_fd_sc_hd__fill_1
XFILLER_0_8_221 VPWR VGND VPWR VGND sky130_ef_sc_hd__decap_12
X_1018_ net158 _0526_ _0527_ net160 VGND VGND VPWR VPWR _0063_ sky130_fd_sc_hd__a22o_1
XFILLER_0_8_265 VPWR VGND VPWR VGND sky130_ef_sc_hd__decap_12
XFILLER_0_39_146 VGND VGND VPWR VPWR sky130_fd_sc_hd__decap_8
XFILLER_0_39_113 VGND VGND VPWR VPWR sky130_fd_sc_hd__fill_1
XFILLER_0_40_29 VGND VGND VPWR VPWR sky130_fd_sc_hd__fill_2
XFILLER_0_40_18 VGND VGND VPWR VPWR sky130_fd_sc_hd__decap_6
XFILLER_0_4_29 VPWR VGND VPWR VGND sky130_ef_sc_hd__decap_12
XFILLER_0_39_93 VGND VGND VPWR VPWR sky130_fd_sc_hd__decap_8
XTAP_230 VGND VPWR sky130_fd_sc_hd__tapvpwrvgnd_1
XTAP_241 VGND VPWR sky130_fd_sc_hd__tapvpwrvgnd_1
X_1498_ clknet_4_14_0_clk _0160_ VGND VGND VPWR VPWR net112 sky130_fd_sc_hd__dfxtp_2
XTAP_296 VGND VPWR sky130_fd_sc_hd__tapvpwrvgnd_1
XTAP_285 VGND VPWR sky130_fd_sc_hd__tapvpwrvgnd_1
XTAP_274 VGND VPWR sky130_fd_sc_hd__tapvpwrvgnd_1
XTAP_252 VGND VPWR sky130_fd_sc_hd__tapvpwrvgnd_1
XTAP_263 VGND VPWR sky130_fd_sc_hd__tapvpwrvgnd_1
XFILLER_0_27_138 VGND VGND VPWR VPWR sky130_fd_sc_hd__fill_1
XFILLER_0_50_141 VPWR VGND VPWR VGND sky130_ef_sc_hd__decap_12
X_1421_ clknet_4_5_0_clk _0084_ VGND VGND VPWR VPWR net79 sky130_fd_sc_hd__dfxtp_2
X_1283_ _0222_ net8 _0203_ VGND VGND VPWR VPWR _0223_ sky130_fd_sc_hd__mux2_1
X_1352_ clknet_4_14_0_clk _0018_ VGND VGND VPWR VPWR rf_ram_if.wen1_r sky130_fd_sc_hd__dfxtp_1
XFILLER_0_41_185 VPWR VGND VPWR VGND sky130_ef_sc_hd__decap_12
XFILLER_0_33_119 VGND VGND VPWR VPWR sky130_fd_sc_hd__decap_6
X_0998_ net139 _0524_ _0525_ net140 VGND VGND VPWR VPWR _0045_ sky130_fd_sc_hd__a22o_1
XFILLER_0_32_141 VPWR VGND VPWR VGND sky130_ef_sc_hd__decap_12
X_0921_ _0388_ _0331_ _0408_ _0406_ VGND VGND VPWR VPWR _0477_ sky130_fd_sc_hd__o31a_1
XFILLER_0_11_53 VGND VGND VPWR VPWR sky130_fd_sc_hd__decap_3
XFILLER_0_11_97 VGND VGND VPWR VPWR sky130_fd_sc_hd__decap_6
XFILLER_0_23_141 VGND VGND VPWR VPWR sky130_fd_sc_hd__decap_3
X_0783_ rf_ram_if.rdata1 net65 rf_ram_if.rtrig1 VGND VGND VPWR VPWR _0365_ sky130_fd_sc_hd__mux2_2
X_0852_ _0419_ VGND VGND VPWR VPWR _0420_ sky130_fd_sc_hd__buf_4
X_1335_ clknet_4_5_0_clk cpu.o_wdata1 VGND VGND VPWR VPWR rf_ram_if.wdata1_r\[2\]
+ sky130_fd_sc_hd__dfxtp_1
X_1404_ clknet_4_0_0_clk _0067_ VGND VGND VPWR VPWR net92 sky130_fd_sc_hd__dfxtp_1
XFILLER_0_36_83 VGND VGND VPWR VPWR sky130_fd_sc_hd__fill_1
X_1266_ _0572_ VGND VGND VPWR VPWR _0211_ sky130_fd_sc_hd__buf_4
Xinput2 i_dbus_rdt[0] VGND VGND VPWR VPWR net2 sky130_fd_sc_hd__buf_1
X_1197_ _0290_ _0289_ cpu.immdec.gen_immdec_w_eq_1.imm7 _0647_ _0448_ VGND VGND VPWR
+ VPWR _0648_ sky130_fd_sc_hd__o311a_1
XFILLER_0_46_288 VPWR VGND VPWR VGND sky130_ef_sc_hd__decap_12
XFILLER_0_14_141 VPWR VGND VPWR VGND sky130_ef_sc_hd__decap_12
XFILLER_0_37_222 VGND VGND VPWR VPWR sky130_fd_sc_hd__fill_2
XFILLER_0_52_258 VGND VGND VPWR VPWR sky130_fd_sc_hd__decap_4
XFILLER_0_20_133 VGND VGND VPWR VPWR sky130_fd_sc_hd__decap_6
X_1120_ net121 _0565_ _0567_ VGND VGND VPWR VPWR _0593_ sky130_fd_sc_hd__o21ba_1
X_1051_ net74 net75 _0539_ VGND VGND VPWR VPWR _0545_ sky130_fd_sc_hd__mux2_1
XFILLER_0_43_225 VGND VGND VPWR VPWR sky130_fd_sc_hd__decap_3
X_0904_ net181 _0445_ VGND VGND VPWR VPWR _0464_ sky130_fd_sc_hd__nand2_1
XFILLER_0_22_41 VGND VGND VPWR VPWR sky130_fd_sc_hd__decap_4
XFILLER_0_22_74 VGND VGND VPWR VPWR sky130_fd_sc_hd__decap_8
XFILLER_0_22_85 VPWR VGND VPWR VGND sky130_ef_sc_hd__decap_12
X_0697_ _0283_ VGND VGND VPWR VPWR net186 sky130_fd_sc_hd__clkbuf_1
X_0766_ net100 net130 net107 net116 cpu.bufreg.data\[0\] cpu.bufreg.data\[1\] VGND
+ VGND VPWR VPWR _0348_ sky130_fd_sc_hd__mux4_1
X_0835_ cpu.branch_op _0338_ _0407_ VGND VGND VPWR VPWR _0408_ sky130_fd_sc_hd__and3_1
XFILLER_0_37_3 VGND VGND VPWR VPWR sky130_fd_sc_hd__fill_1
X_1318_ _0311_ _0312_ _0332_ VGND VGND VPWR VPWR _0244_ sky130_fd_sc_hd__nand3_1
X_1249_ _0199_ VGND VGND VPWR VPWR _0144_ sky130_fd_sc_hd__clkbuf_1
XFILLER_0_19_288 VGND VGND VPWR VPWR sky130_fd_sc_hd__decap_4
Xoutput191 net191 VGND VGND VPWR VPWR o_wdata[1] sky130_fd_sc_hd__clkbuf_4
Xoutput180 net180 VGND VGND VPWR VPWR o_waddr[0] sky130_fd_sc_hd__clkbuf_4
XFILLER_0_27_19 VGND VGND VPWR VPWR sky130_fd_sc_hd__decap_8
XPHY_8 VGND VGND VPWR VPWR sky130_fd_sc_hd__decap_3
X_1103_ _0567_ VGND VGND VPWR VPWR _0579_ sky130_fd_sc_hd__buf_4
X_1034_ net96 net97 _0342_ VGND VGND VPWR VPWR _0536_ sky130_fd_sc_hd__mux2_1
XFILLER_0_17_74 VGND VGND VPWR VPWR sky130_fd_sc_hd__fill_1
XFILLER_0_31_217 VGND VGND VPWR VPWR sky130_fd_sc_hd__decap_6
XFILLER_0_16_203 VGND VGND VPWR VPWR sky130_fd_sc_hd__fill_1
Xinput60 i_ibus_rdt[5] VGND VGND VPWR VPWR net60 sky130_fd_sc_hd__clkbuf_1
X_0818_ _0382_ _0396_ _0397_ VGND VGND VPWR VPWR _0398_ sky130_fd_sc_hd__mux2_1
X_0749_ _0314_ _0328_ _0330_ VGND VGND VPWR VPWR _0331_ sky130_fd_sc_hd__a21oi_1
XFILLER_0_22_206 VGND VGND VPWR VPWR sky130_fd_sc_hd__decap_6
XFILLER_0_38_29 VGND VGND VPWR VPWR sky130_fd_sc_hd__fill_2
XTAP_401 VGND VPWR sky130_fd_sc_hd__tapvpwrvgnd_1
XFILLER_0_0_111 VGND VGND VPWR VPWR sky130_fd_sc_hd__fill_1
XFILLER_0_0_133 VGND VGND VPWR VPWR sky130_fd_sc_hd__fill_1
XFILLER_0_28_62 VGND VGND VPWR VPWR sky130_fd_sc_hd__decap_6
XFILLER_0_44_94 VPWR VGND VPWR VGND sky130_ef_sc_hd__decap_12
XFILLER_0_36_309 VGND VGND VPWR VPWR sky130_fd_sc_hd__fill_1
XFILLER_0_8_233 VPWR VGND VPWR VGND sky130_ef_sc_hd__decap_12
X_1017_ net157 _0526_ _0527_ net158 VGND VGND VPWR VPWR _0062_ sky130_fd_sc_hd__a22o_1
XFILLER_0_8_277 VPWR VGND VPWR VGND sky130_ef_sc_hd__decap_12
XFILLER_0_47_191 VPWR VGND VPWR VGND sky130_ef_sc_hd__decap_12
XFILLER_0_39_169 VPWR VGND VPWR VGND sky130_ef_sc_hd__decap_12
XFILLER_0_39_158 VGND VGND VPWR VPWR sky130_fd_sc_hd__decap_8
XFILLER_0_18_309 VGND VGND VPWR VPWR sky130_fd_sc_hd__fill_2
XFILLER_0_38_191 VGND VGND VPWR VPWR sky130_fd_sc_hd__decap_4
XFILLER_0_30_85 VPWR VGND VPWR VGND sky130_ef_sc_hd__decap_12
XFILLER_0_30_63 VGND VGND VPWR VPWR sky130_fd_sc_hd__decap_8
XFILLER_0_30_52 VGND VGND VPWR VPWR sky130_fd_sc_hd__fill_2
XFILLER_0_30_41 VGND VGND VPWR VPWR sky130_fd_sc_hd__decap_6
X_1497_ clknet_4_15_0_clk _0159_ VGND VGND VPWR VPWR net110 sky130_fd_sc_hd__dfxtp_1
XTAP_275 VGND VPWR sky130_fd_sc_hd__tapvpwrvgnd_1
XTAP_220 VGND VPWR sky130_fd_sc_hd__tapvpwrvgnd_1
XTAP_231 VGND VPWR sky130_fd_sc_hd__tapvpwrvgnd_1
XTAP_242 VGND VPWR sky130_fd_sc_hd__tapvpwrvgnd_1
XTAP_253 VGND VPWR sky130_fd_sc_hd__tapvpwrvgnd_1
XTAP_264 VGND VPWR sky130_fd_sc_hd__tapvpwrvgnd_1
XTAP_297 VGND VPWR sky130_fd_sc_hd__tapvpwrvgnd_1
XTAP_286 VGND VPWR sky130_fd_sc_hd__tapvpwrvgnd_1
XFILLER_0_51_109 VGND VGND VPWR VPWR sky130_fd_sc_hd__decap_3
XFILLER_0_36_128 VPWR VGND VPWR VGND sky130_ef_sc_hd__decap_12
XFILLER_0_36_106 VGND VGND VPWR VPWR sky130_fd_sc_hd__fill_1
XFILLER_0_51_29 VPWR VGND VPWR VGND sky130_ef_sc_hd__decap_12
XFILLER_0_35_172 VGND VGND VPWR VPWR sky130_fd_sc_hd__decap_6
XFILLER_0_50_197 VPWR VGND VPWR VGND sky130_ef_sc_hd__decap_12
XFILLER_0_50_153 VPWR VGND VPWR VGND sky130_ef_sc_hd__decap_12
X_1420_ clknet_4_15_0_clk _0083_ VGND VGND VPWR VPWR net78 sky130_fd_sc_hd__dfxtp_1
X_1351_ clknet_4_1_0_clk _0017_ VGND VGND VPWR VPWR cpu.bufreg.data\[1\] sky130_fd_sc_hd__dfxtp_2
X_1282_ net106 net107 _0211_ VGND VGND VPWR VPWR _0222_ sky130_fd_sc_hd__mux2_1
XFILLER_0_41_197 VGND VGND VPWR VPWR sky130_fd_sc_hd__decap_8
XFILLER_0_1_261 VPWR VGND VPWR VGND sky130_ef_sc_hd__decap_12
X_0997_ net138 _0524_ _0525_ net139 VGND VGND VPWR VPWR _0044_ sky130_fd_sc_hd__a22o_1
XFILLER_0_49_220 VGND VGND VPWR VPWR sky130_fd_sc_hd__decap_4
XFILLER_0_32_120 VPWR VGND VPWR VGND sky130_ef_sc_hd__decap_12
XFILLER_0_17_194 VGND VGND VPWR VPWR sky130_fd_sc_hd__decap_8
XFILLER_0_32_153 VGND VGND VPWR VPWR sky130_fd_sc_hd__decap_4
XFILLER_0_46_29 VPWR VGND VPWR VGND sky130_ef_sc_hd__decap_12
X_0920_ _0476_ VGND VGND VPWR VPWR _0016_ sky130_fd_sc_hd__clkbuf_1
X_0782_ cpu.decode.op21 _0363_ _0262_ VGND VGND VPWR VPWR _0364_ sky130_fd_sc_hd__and3_1
X_0851_ net34 VGND VGND VPWR VPWR _0419_ sky130_fd_sc_hd__clkbuf_4
X_1265_ _0210_ VGND VGND VPWR VPWR _0149_ sky130_fd_sc_hd__clkbuf_1
X_1334_ clknet_4_5_0_clk net197 VGND VGND VPWR VPWR rf_ram_if.wdata1_r\[1\] sky130_fd_sc_hd__dfxtp_1
X_1403_ clknet_4_0_0_clk _0066_ VGND VGND VPWR VPWR net89 sky130_fd_sc_hd__dfxtp_2
Xinput3 i_dbus_rdt[10] VGND VGND VPWR VPWR net3 sky130_fd_sc_hd__clkbuf_1
XFILLER_0_36_40 VPWR VGND VPWR VGND sky130_ef_sc_hd__decap_12
X_1196_ _0288_ _0307_ cpu.immdec.gen_immdec_w_eq_1.imm19_12_20\[0\] _0645_ _0646_
+ VGND VGND VPWR VPWR _0647_ sky130_fd_sc_hd__a221o_1
XFILLER_0_52_72 VGND VGND VPWR VPWR sky130_fd_sc_hd__fill_1
XFILLER_0_14_153 VGND VGND VPWR VPWR sky130_fd_sc_hd__decap_6
XFILLER_0_14_197 VGND VGND VPWR VPWR sky130_fd_sc_hd__decap_6
XFILLER_0_9_180 VPWR VGND VPWR VGND sky130_ef_sc_hd__decap_12
X_1050_ _0544_ VGND VGND VPWR VPWR _0078_ sky130_fd_sc_hd__clkbuf_1
XFILLER_0_3_301 VGND VGND VPWR VPWR sky130_fd_sc_hd__fill_1
X_0903_ net181 _0445_ VGND VGND VPWR VPWR _0463_ sky130_fd_sc_hd__or2_1
X_0834_ _0289_ cpu.decode.opcode\[1\] VGND VGND VPWR VPWR _0407_ sky130_fd_sc_hd__xnor2_1
XFILLER_0_22_97 VGND VGND VPWR VPWR sky130_fd_sc_hd__decap_4
XFILLER_0_51_292 VGND VGND VPWR VPWR sky130_fd_sc_hd__fill_2
XFILLER_0_51_281 VGND VGND VPWR VPWR sky130_fd_sc_hd__decap_8
X_0696_ cpu.immdec.gen_immdec_w_eq_1.imm11_7\[2\] _0280_ VGND VGND VPWR VPWR _0283_
+ sky130_fd_sc_hd__and2_1
X_0765_ _0298_ _0346_ cpu.mem_if.signbit VGND VGND VPWR VPWR _0347_ sky130_fd_sc_hd__or3b_1
XFILLER_0_2_41 VPWR VGND VPWR VGND sky130_ef_sc_hd__decap_12
X_1248_ _0198_ net28 _0579_ VGND VGND VPWR VPWR _0199_ sky130_fd_sc_hd__mux2_1
X_1317_ _0349_ _0347_ VGND VGND VPWR VPWR _0168_ sky130_fd_sc_hd__nand2_1
X_1179_ _0388_ net136 _0325_ VGND VGND VPWR VPWR _0635_ sky130_fd_sc_hd__or3_1
XFILLER_0_42_281 VGND VGND VPWR VPWR sky130_fd_sc_hd__decap_8
Xoutput170 net170 VGND VGND VPWR VPWR o_raddr[0] sky130_fd_sc_hd__clkbuf_4
Xoutput192 net192 VGND VGND VPWR VPWR o_wen sky130_fd_sc_hd__buf_2
Xoutput181 net181 VGND VGND VPWR VPWR o_waddr[1] sky130_fd_sc_hd__clkbuf_4
XPHY_9 VGND VGND VPWR VPWR sky130_fd_sc_hd__decap_3
XFILLER_0_4_109 VGND VGND VPWR VPWR sky130_fd_sc_hd__decap_6
X_1102_ _0576_ _0577_ _0565_ VGND VGND VPWR VPWR _0578_ sky130_fd_sc_hd__mux2_1
XFILLER_0_33_74 VPWR VGND VPWR VGND sky130_ef_sc_hd__decap_12
X_1033_ _0535_ VGND VGND VPWR VPWR _0070_ sky130_fd_sc_hd__clkbuf_1
XFILLER_0_16_9 VGND VGND VPWR VPWR sky130_fd_sc_hd__decap_3
X_0817_ _0322_ VGND VGND VPWR VPWR _0397_ sky130_fd_sc_hd__clkbuf_4
Xinput61 i_ibus_rdt[6] VGND VGND VPWR VPWR net61 sky130_fd_sc_hd__clkbuf_1
Xinput50 i_ibus_rdt[25] VGND VGND VPWR VPWR net50 sky130_fd_sc_hd__clkbuf_1
XFILLER_0_16_226 VGND VGND VPWR VPWR sky130_fd_sc_hd__decap_6
XFILLER_0_16_248 VGND VGND VPWR VPWR sky130_fd_sc_hd__decap_4
X_0679_ cpu.decode.op26 cpu.decode.co_ebreak _0262_ _0267_ _0273_ VGND VGND VPWR VPWR
+ _0274_ sky130_fd_sc_hd__a311o_1
X_0748_ _0259_ _0260_ _0309_ cpu.immdec.gen_immdec_w_eq_1.imm31 _0329_ VGND VGND VPWR
+ VPWR _0330_ sky130_fd_sc_hd__o311a_1
XFILLER_0_39_307 VGND VGND VPWR VPWR sky130_fd_sc_hd__fill_1
XFILLER_0_30_262 VGND VGND VPWR VPWR sky130_fd_sc_hd__decap_4
XFILLER_0_15_281 VGND VGND VPWR VPWR sky130_fd_sc_hd__decap_8
XFILLER_0_13_218 VGND VGND VPWR VPWR sky130_fd_sc_hd__decap_6
XTAP_402 VGND VPWR sky130_fd_sc_hd__tapvpwrvgnd_1
XFILLER_0_44_40 VGND VGND VPWR VPWR sky130_fd_sc_hd__decap_3
XFILLER_0_8_245 VGND VGND VPWR VPWR sky130_fd_sc_hd__decap_6
X_1016_ net207 _0526_ _0527_ net157 VGND VGND VPWR VPWR _0061_ sky130_fd_sc_hd__a22o_1
XFILLER_0_8_289 VPWR VGND VPWR VGND sky130_ef_sc_hd__decap_12
XFILLER_0_12_251 VGND VGND VPWR VPWR sky130_fd_sc_hd__fill_1
XFILLER_0_39_137 VGND VGND VPWR VPWR sky130_fd_sc_hd__decap_6
XFILLER_0_30_97 VPWR VGND VPWR VGND sky130_ef_sc_hd__decap_12
X_1496_ clknet_4_14_0_clk _0158_ VGND VGND VPWR VPWR net109 sky130_fd_sc_hd__dfxtp_1
XTAP_298 VGND VPWR sky130_fd_sc_hd__tapvpwrvgnd_1
XTAP_287 VGND VPWR sky130_fd_sc_hd__tapvpwrvgnd_1
XTAP_276 VGND VPWR sky130_fd_sc_hd__tapvpwrvgnd_1
XTAP_265 VGND VPWR sky130_fd_sc_hd__tapvpwrvgnd_1
XTAP_210 VGND VPWR sky130_fd_sc_hd__tapvpwrvgnd_1
XTAP_221 VGND VPWR sky130_fd_sc_hd__tapvpwrvgnd_1
XTAP_232 VGND VPWR sky130_fd_sc_hd__tapvpwrvgnd_1
XTAP_243 VGND VPWR sky130_fd_sc_hd__tapvpwrvgnd_1
XTAP_254 VGND VPWR sky130_fd_sc_hd__tapvpwrvgnd_1
XFILLER_0_3_6 VPWR VGND VPWR VGND sky130_ef_sc_hd__decap_12
XFILLER_0_27_107 VGND VGND VPWR VPWR sky130_fd_sc_hd__decap_4
XFILLER_0_50_165 VPWR VGND VPWR VGND sky130_ef_sc_hd__decap_12
XFILLER_0_50_121 VPWR VGND VPWR VGND sky130_ef_sc_hd__decap_12
X_1281_ _0221_ VGND VGND VPWR VPWR _0154_ sky130_fd_sc_hd__clkbuf_1
X_1350_ clknet_4_2_0_clk _0016_ VGND VGND VPWR VPWR cpu.bufreg.data\[0\] sky130_fd_sc_hd__dfxtp_4
XFILLER_0_14_313 VGND VGND VPWR VPWR sky130_fd_sc_hd__fill_1
X_0996_ _0522_ VGND VGND VPWR VPWR _0525_ sky130_fd_sc_hd__buf_2
XFILLER_0_41_154 VGND VGND VPWR VPWR sky130_fd_sc_hd__fill_2
XFILLER_0_1_273 VGND VGND VPWR VPWR sky130_fd_sc_hd__decap_6
X_1479_ clknet_4_9_0_clk _0141_ VGND VGND VPWR VPWR net111 sky130_fd_sc_hd__dfxtp_1
XFILLER_0_32_132 VGND VGND VPWR VPWR sky130_fd_sc_hd__decap_8
XFILLER_0_1_3 VGND VGND VPWR VPWR sky130_fd_sc_hd__decap_4
X_0850_ net173 _0417_ VGND VGND VPWR VPWR net183 sky130_fd_sc_hd__xnor2_1
X_0781_ cpu.decode.co_ebreak VGND VGND VPWR VPWR _0363_ sky130_fd_sc_hd__inv_2
X_1402_ clknet_4_7_0_clk _0004_ VGND VGND VPWR VPWR cpu.ctrl.pc_plus_offset_cy_r sky130_fd_sc_hd__dfxtp_1
XFILLER_0_11_305 VGND VGND VPWR VPWR sky130_fd_sc_hd__decap_6
XFILLER_0_46_9 VPWR VGND VPWR VGND sky130_ef_sc_hd__decap_12
X_1264_ _0209_ net33 _0203_ VGND VGND VPWR VPWR _0210_ sky130_fd_sc_hd__mux2_1
XFILLER_0_36_52 VGND VGND VPWR VPWR sky130_fd_sc_hd__decap_6
X_1333_ clknet_4_5_0_clk net198 VGND VGND VPWR VPWR rf_ram_if.wdata1_r\[0\] sky130_fd_sc_hd__dfxtp_1
Xinput4 i_dbus_rdt[11] VGND VGND VPWR VPWR net4 sky130_fd_sc_hd__buf_1
XFILLER_0_52_62 VGND VGND VPWR VPWR sky130_fd_sc_hd__decap_4
XFILLER_0_52_51 VGND VGND VPWR VPWR sky130_fd_sc_hd__fill_1
XFILLER_0_36_85 VGND VGND VPWR VPWR sky130_fd_sc_hd__decap_4
XFILLER_0_36_74 VGND VGND VPWR VPWR sky130_fd_sc_hd__decap_3
X_1195_ _0627_ _0645_ VGND VGND VPWR VPWR _0646_ sky130_fd_sc_hd__nor2_1
X_0979_ _0515_ net36 VGND VGND VPWR VPWR _0519_ sky130_fd_sc_hd__and2_1
XFILLER_0_14_110 VGND VGND VPWR VPWR sky130_fd_sc_hd__fill_1
XFILLER_0_14_121 VPWR VGND VPWR VGND sky130_ef_sc_hd__decap_12
XFILLER_0_14_187 VGND VGND VPWR VPWR sky130_fd_sc_hd__decap_8
XFILLER_0_37_279 VGND VGND VPWR VPWR sky130_fd_sc_hd__fill_1
XFILLER_0_37_257 VGND VGND VPWR VPWR sky130_fd_sc_hd__decap_3
XFILLER_0_37_202 VPWR VGND VPWR VGND sky130_ef_sc_hd__decap_12
XFILLER_0_9_192 VGND VGND VPWR VPWR sky130_fd_sc_hd__fill_1
XFILLER_0_20_102 VPWR VGND VPWR VGND sky130_ef_sc_hd__decap_12
XFILLER_0_28_202 VGND VGND VPWR VPWR sky130_fd_sc_hd__decap_8
X_0833_ _0404_ _0405_ VGND VGND VPWR VPWR _0406_ sky130_fd_sc_hd__or2_1
XFILLER_0_22_10 VGND VGND VPWR VPWR sky130_fd_sc_hd__fill_2
X_0902_ _0462_ VGND VGND VPWR VPWR _0012_ sky130_fd_sc_hd__clkbuf_1
X_0695_ _0276_ cpu.decode.op26 cpu.decode.co_ebreak _0266_ _0282_ VGND VGND VPWR VPWR
+ net185 sky130_fd_sc_hd__a311o_1
XFILLER_0_11_113 VPWR VGND VPWR VGND sky130_ef_sc_hd__decap_12
XFILLER_0_11_146 VGND VGND VPWR VPWR sky130_fd_sc_hd__decap_3
X_0764_ _0332_ _0345_ _0311_ VGND VGND VPWR VPWR _0346_ sky130_fd_sc_hd__a21oi_1
X_1316_ cpu.state.gen_csr.misalign_trap_sync_r _0437_ _0452_ VGND VGND VPWR VPWR _0167_
+ sky130_fd_sc_hd__o21a_1
XFILLER_0_2_53 VPWR VGND VPWR VGND sky130_ef_sc_hd__decap_12
X_1247_ net126 net127 _0189_ VGND VGND VPWR VPWR _0198_ sky130_fd_sc_hd__mux2_1
X_1178_ cpu.immdec.gen_immdec_w_eq_1.imm30_25\[1\] net50 _0614_ VGND VGND VPWR VPWR
+ _0634_ sky130_fd_sc_hd__mux2_1
XFILLER_0_34_205 VGND VGND VPWR VPWR sky130_fd_sc_hd__fill_2
XFILLER_0_34_249 VGND VGND VPWR VPWR sky130_fd_sc_hd__decap_3
XFILLER_0_6_173 VGND VGND VPWR VPWR sky130_fd_sc_hd__decap_8
Xoutput182 net182 VGND VGND VPWR VPWR o_waddr[2] sky130_fd_sc_hd__clkbuf_4
Xoutput160 net160 VGND VGND VPWR VPWR o_ibus_adr[30] sky130_fd_sc_hd__clkbuf_4
Xoutput171 net171 VGND VGND VPWR VPWR o_raddr[1] sky130_fd_sc_hd__clkbuf_4
XFILLER_0_40_219 VGND VGND VPWR VPWR sky130_fd_sc_hd__fill_2
X_1032_ net95 net96 _0342_ VGND VGND VPWR VPWR _0535_ sky130_fd_sc_hd__mux2_1
X_1101_ net116 net117 VGND VGND VPWR VPWR _0577_ sky130_fd_sc_hd__xnor2_1
XFILLER_0_33_86 VPWR VGND VPWR VGND sky130_ef_sc_hd__decap_12
XFILLER_0_33_31 VPWR VGND VPWR VGND sky130_ef_sc_hd__decap_12
Xinput40 i_ibus_rdt[15] VGND VGND VPWR VPWR net40 sky130_fd_sc_hd__buf_1
X_0747_ cpu.state.cnt_r\[3\] cpu.bufreg2.i_bytecnt\[1\] cpu.state.o_cnt\[2\] cpu.bufreg2.i_bytecnt\[0\]
+ VGND VGND VPWR VPWR _0329_ sky130_fd_sc_hd__and4_1
Xinput51 i_ibus_rdt[26] VGND VGND VPWR VPWR net51 sky130_fd_sc_hd__buf_1
X_0816_ _0378_ _0385_ _0379_ VGND VGND VPWR VPWR _0396_ sky130_fd_sc_hd__a21bo_1
Xinput62 i_ibus_rdt[7] VGND VGND VPWR VPWR net62 sky130_fd_sc_hd__buf_1
X_0678_ _0263_ _0272_ cpu.immdec.gen_immdec_w_eq_1.imm24_20\[1\] VGND VGND VPWR VPWR
+ _0273_ sky130_fd_sc_hd__and3b_1
XFILLER_0_15_260 VGND VGND VPWR VPWR sky130_fd_sc_hd__decap_8
XTAP_403 VGND VPWR sky130_fd_sc_hd__tapvpwrvgnd_1
XFILLER_0_0_113 VGND VGND VPWR VPWR sky130_fd_sc_hd__fill_1
XFILLER_0_0_146 VGND VGND VPWR VPWR sky130_fd_sc_hd__fill_2
XFILLER_0_44_52 VGND VGND VPWR VPWR sky130_fd_sc_hd__decap_4
X_1015_ net155 _0526_ _0527_ net204 VGND VGND VPWR VPWR _0060_ sky130_fd_sc_hd__a22o_1
XFILLER_0_8_41 VGND VGND VPWR VPWR sky130_fd_sc_hd__decap_6
XFILLER_0_8_63 VGND VGND VPWR VPWR sky130_fd_sc_hd__fill_2
XFILLER_0_8_85 VGND VGND VPWR VPWR sky130_fd_sc_hd__decap_4
XFILLER_0_12_241 VGND VGND VPWR VPWR sky130_fd_sc_hd__fill_1
XFILLER_0_14_55 VGND VGND VPWR VPWR sky130_fd_sc_hd__fill_1
X_1495_ clknet_4_15_0_clk _0157_ VGND VGND VPWR VPWR net108 sky130_fd_sc_hd__dfxtp_1
XTAP_299 VGND VPWR sky130_fd_sc_hd__tapvpwrvgnd_1
XTAP_288 VGND VPWR sky130_fd_sc_hd__tapvpwrvgnd_1
XTAP_277 VGND VPWR sky130_fd_sc_hd__tapvpwrvgnd_1
XTAP_266 VGND VPWR sky130_fd_sc_hd__tapvpwrvgnd_1
XTAP_200 VGND VPWR sky130_fd_sc_hd__tapvpwrvgnd_1
XTAP_211 VGND VPWR sky130_fd_sc_hd__tapvpwrvgnd_1
XTAP_222 VGND VPWR sky130_fd_sc_hd__tapvpwrvgnd_1
XTAP_233 VGND VPWR sky130_fd_sc_hd__tapvpwrvgnd_1
XTAP_244 VGND VPWR sky130_fd_sc_hd__tapvpwrvgnd_1
XTAP_255 VGND VPWR sky130_fd_sc_hd__tapvpwrvgnd_1
XFILLER_0_44_141 VPWR VGND VPWR VGND sky130_ef_sc_hd__decap_12
XFILLER_0_50_177 VPWR VGND VPWR VGND sky130_ef_sc_hd__decap_12
XFILLER_0_50_133 VGND VGND VPWR VPWR sky130_fd_sc_hd__decap_6
XFILLER_0_35_185 VGND VGND VPWR VPWR sky130_fd_sc_hd__fill_1
XFILLER_0_35_163 VGND VGND VPWR VPWR sky130_fd_sc_hd__decap_4
X_1280_ _0220_ net7 _0203_ VGND VGND VPWR VPWR _0221_ sky130_fd_sc_hd__mux2_1
XFILLER_0_25_21 VGND VGND VPWR VPWR sky130_fd_sc_hd__decap_3
XFILLER_0_25_98 VGND VGND VPWR VPWR sky130_fd_sc_hd__fill_1
XFILLER_0_18_119 VGND VGND VPWR VPWR sky130_fd_sc_hd__decap_6
X_0995_ _0453_ VGND VGND VPWR VPWR _0524_ sky130_fd_sc_hd__buf_2
XFILLER_0_26_141 VPWR VGND VPWR VGND sky130_ef_sc_hd__decap_12
X_1478_ clknet_4_8_0_clk _0140_ VGND VGND VPWR VPWR net100 sky130_fd_sc_hd__dfxtp_1
XFILLER_0_32_100 VGND VGND VPWR VPWR sky130_fd_sc_hd__fill_1
XFILLER_0_17_141 VGND VGND VPWR VPWR sky130_fd_sc_hd__fill_2
XFILLER_0_17_152 VPWR VGND VPWR VGND sky130_ef_sc_hd__decap_12
X_0780_ cpu.gen_csr.csr.mcause31 _0329_ _0337_ cpu.gen_csr.csr.mcause3_0\[0\] VGND
+ VGND VPWR VPWR _0362_ sky130_fd_sc_hd__a22o_1
XFILLER_0_11_45 VGND VGND VPWR VPWR sky130_fd_sc_hd__decap_8
XFILLER_0_23_111 VGND VGND VPWR VPWR sky130_fd_sc_hd__fill_1
XFILLER_0_23_122 VGND VGND VPWR VPWR sky130_fd_sc_hd__fill_2
X_1401_ clknet_4_4_0_clk _0003_ VGND VGND VPWR VPWR cpu.ctrl.pc_plus_4_cy_r sky130_fd_sc_hd__dfxtp_1
XFILLER_0_23_166 VGND VGND VPWR VPWR sky130_fd_sc_hd__fill_2
XFILLER_0_23_188 VGND VGND VPWR VPWR sky130_fd_sc_hd__fill_1
X_1263_ net131 net101 _0189_ VGND VGND VPWR VPWR _0209_ sky130_fd_sc_hd__mux2_1
Xinput5 i_dbus_rdt[12] VGND VGND VPWR VPWR net5 sky130_fd_sc_hd__buf_1
X_1194_ _0289_ _0388_ cpu.decode.opcode\[1\] VGND VGND VPWR VPWR _0645_ sky130_fd_sc_hd__a21o_1
X_1332_ clknet_4_4_0_clk _0005_ VGND VGND VPWR VPWR rf_ram_if.rreq_r sky130_fd_sc_hd__dfxtp_1
X_0978_ cpu.immdec.gen_immdec_w_eq_1.imm11_7\[3\] _0512_ _0514_ cpu.immdec.gen_immdec_w_eq_1.imm11_7\[4\]
+ _0518_ VGND VGND VPWR VPWR _0032_ sky130_fd_sc_hd__a221o_1
XFILLER_0_14_133 VGND VGND VPWR VPWR sky130_fd_sc_hd__fill_1
XFILLER_0_37_225 VGND VGND VPWR VPWR sky130_fd_sc_hd__fill_2
XFILLER_0_37_214 VGND VGND VPWR VPWR sky130_fd_sc_hd__decap_8
XFILLER_0_20_114 VGND VGND VPWR VPWR sky130_fd_sc_hd__decap_3
XFILLER_0_51_261 VPWR VGND VPWR VGND sky130_ef_sc_hd__decap_12
XFILLER_0_36_291 VPWR VGND VPWR VGND sky130_ef_sc_hd__decap_12
X_0832_ cpu.alu.i_rs1 _0403_ cpu.bufreg.c_r VGND VGND VPWR VPWR _0405_ sky130_fd_sc_hd__a21oi_1
X_0763_ cpu.bne_or_bge VGND VGND VPWR VPWR _0345_ sky130_fd_sc_hd__inv_2
XFILLER_0_22_55 VPWR VGND VPWR VGND sky130_ef_sc_hd__decap_12
X_0901_ _0276_ _0461_ VGND VGND VPWR VPWR _0462_ sky130_fd_sc_hd__and2b_1
X_0694_ _0252_ cpu.immdec.gen_immdec_w_eq_1.imm11_7\[1\] VGND VGND VPWR VPWR _0282_
+ sky130_fd_sc_hd__and2b_1
X_1315_ _0243_ VGND VGND VPWR VPWR _0166_ sky130_fd_sc_hd__clkbuf_1
XFILLER_0_11_125 VGND VGND VPWR VPWR sky130_fd_sc_hd__decap_4
XFILLER_0_11_158 VGND VGND VPWR VPWR sky130_fd_sc_hd__decap_6
X_1246_ _0197_ VGND VGND VPWR VPWR _0143_ sky130_fd_sc_hd__clkbuf_1
XFILLER_0_2_65 VPWR VGND VPWR VGND sky130_ef_sc_hd__decap_12
X_1177_ _0448_ net62 _0632_ _0633_ VGND VGND VPWR VPWR _0116_ sky130_fd_sc_hd__o22a_1
XFILLER_0_6_141 VGND VGND VPWR VPWR sky130_fd_sc_hd__decap_6
XFILLER_0_19_225 VGND VGND VPWR VPWR sky130_fd_sc_hd__fill_1
XFILLER_0_19_247 VPWR VGND VPWR VGND sky130_ef_sc_hd__decap_12
Xoutput161 net161 VGND VGND VPWR VPWR o_ibus_adr[31] sky130_fd_sc_hd__clkbuf_4
XFILLER_0_42_261 VGND VGND VPWR VPWR sky130_fd_sc_hd__fill_2
Xoutput150 net150 VGND VGND VPWR VPWR o_ibus_adr[21] sky130_fd_sc_hd__clkbuf_4
Xoutput183 net183 VGND VGND VPWR VPWR o_waddr[3] sky130_fd_sc_hd__clkbuf_4
Xoutput172 net172 VGND VGND VPWR VPWR o_raddr[2] sky130_fd_sc_hd__clkbuf_4
XFILLER_0_0_306 VGND VGND VPWR VPWR sky130_fd_sc_hd__fill_2
Xclkbuf_4_9_0_clk clknet_0_clk VGND VGND VPWR VPWR clknet_4_9_0_clk sky130_fd_sc_hd__clkbuf_8
XFILLER_0_48_309 VGND VGND VPWR VPWR sky130_fd_sc_hd__fill_2
X_1031_ _0534_ VGND VGND VPWR VPWR _0069_ sky130_fd_sc_hd__clkbuf_1
X_1100_ net117 net118 _0572_ VGND VGND VPWR VPWR _0576_ sky130_fd_sc_hd__mux2_1
XFILLER_0_17_88 VPWR VGND VPWR VGND sky130_ef_sc_hd__decap_12
XFILLER_0_33_43 VGND VGND VPWR VPWR sky130_fd_sc_hd__fill_2
Xinput30 i_dbus_rdt[6] VGND VGND VPWR VPWR net30 sky130_fd_sc_hd__buf_1
Xinput63 i_ibus_rdt[8] VGND VGND VPWR VPWR net63 sky130_fd_sc_hd__clkbuf_1
Xinput41 i_ibus_rdt[16] VGND VGND VPWR VPWR net41 sky130_fd_sc_hd__clkbuf_1
X_0815_ net137 _0266_ _0395_ VGND VGND VPWR VPWR cpu.o_wdata1 sky130_fd_sc_hd__a21o_1
XFILLER_0_31_209 VGND VGND VPWR VPWR sky130_fd_sc_hd__fill_1
XFILLER_0_3_188 VPWR VGND VPWR VGND sky130_ef_sc_hd__decap_12
XFILLER_0_3_166 VGND VGND VPWR VPWR sky130_fd_sc_hd__fill_2
XFILLER_0_3_111 VGND VGND VPWR VPWR sky130_fd_sc_hd__fill_1
Xinput52 i_ibus_rdt[27] VGND VGND VPWR VPWR net52 sky130_fd_sc_hd__clkbuf_1
X_0746_ cpu.immdec.gen_immdec_w_eq_1.imm11_7\[0\] cpu.immdec.gen_immdec_w_eq_1.imm24_20\[0\]
+ _0327_ VGND VGND VPWR VPWR _0328_ sky130_fd_sc_hd__mux2_1
X_0677_ cpu.state.gen_csr.misalign_trap_sync_r _0264_ VGND VGND VPWR VPWR _0272_ sky130_fd_sc_hd__nor2_2
XFILLER_0_35_3 VGND VGND VPWR VPWR sky130_fd_sc_hd__decap_3
X_1229_ _0186_ VGND VGND VPWR VPWR _0137_ sky130_fd_sc_hd__clkbuf_1
XTAP_404 VGND VPWR sky130_fd_sc_hd__tapvpwrvgnd_1
XFILLER_0_0_169 VGND VGND VPWR VPWR sky130_fd_sc_hd__fill_2
XFILLER_0_21_275 VGND VGND VPWR VPWR sky130_fd_sc_hd__decap_4
XFILLER_0_44_75 VGND VGND VPWR VPWR sky130_fd_sc_hd__decap_3
X_1014_ net154 _0526_ _0527_ net155 VGND VGND VPWR VPWR _0059_ sky130_fd_sc_hd__a22o_1
X_0729_ cpu.bufreg2.i_bytecnt\[1\] VGND VGND VPWR VPWR _0311_ sky130_fd_sc_hd__clkbuf_4
X_1494_ clknet_4_13_0_clk _0156_ VGND VGND VPWR VPWR net107 sky130_fd_sc_hd__dfxtp_2
XFILLER_0_39_20 VGND VGND VPWR VPWR sky130_fd_sc_hd__fill_2
XTAP_201 VGND VPWR sky130_fd_sc_hd__tapvpwrvgnd_1
XTAP_212 VGND VPWR sky130_fd_sc_hd__tapvpwrvgnd_1
XTAP_223 VGND VPWR sky130_fd_sc_hd__tapvpwrvgnd_1
XFILLER_0_39_86 VGND VGND VPWR VPWR sky130_fd_sc_hd__fill_1
XTAP_289 VGND VPWR sky130_fd_sc_hd__tapvpwrvgnd_1
XTAP_278 VGND VPWR sky130_fd_sc_hd__tapvpwrvgnd_1
XTAP_267 VGND VPWR sky130_fd_sc_hd__tapvpwrvgnd_1
XTAP_234 VGND VPWR sky130_fd_sc_hd__tapvpwrvgnd_1
XTAP_245 VGND VPWR sky130_fd_sc_hd__tapvpwrvgnd_1
XTAP_256 VGND VPWR sky130_fd_sc_hd__tapvpwrvgnd_1
XFILLER_0_44_197 VGND VGND VPWR VPWR sky130_fd_sc_hd__decap_8
XFILLER_0_44_153 VPWR VGND VPWR VGND sky130_ef_sc_hd__decap_12
XFILLER_0_32_304 VGND VGND VPWR VPWR sky130_fd_sc_hd__decap_4
Xmax_cap193 net196 VGND VGND VPWR VPWR net193 sky130_fd_sc_hd__clkbuf_2
XFILLER_0_50_189 VGND VGND VPWR VPWR sky130_fd_sc_hd__decap_6
XFILLER_0_2_209 VPWR VGND VPWR VGND sky130_ef_sc_hd__decap_12
XFILLER_0_41_21 VGND VGND VPWR VPWR sky130_fd_sc_hd__decap_8
XFILLER_0_25_66 VPWR VGND VPWR VGND sky130_ef_sc_hd__decap_12
XFILLER_0_41_167 VGND VGND VPWR VPWR sky130_fd_sc_hd__fill_1
XFILLER_0_41_65 VGND VGND VPWR VPWR sky130_fd_sc_hd__fill_1
X_0994_ net168 _0520_ _0523_ net138 VGND VGND VPWR VPWR _0043_ sky130_fd_sc_hd__a22o_1
XFILLER_0_26_197 VPWR VGND VPWR VGND sky130_ef_sc_hd__decap_12
XFILLER_0_5_32 VGND VGND VPWR VPWR sky130_fd_sc_hd__fill_1
XFILLER_0_1_220 VGND VGND VPWR VPWR sky130_fd_sc_hd__decap_4
X_1477_ clknet_4_11_0_clk _0139_ VGND VGND VPWR VPWR cpu.branch_op sky130_fd_sc_hd__dfxtp_2
XFILLER_0_17_175 VGND VGND VPWR VPWR sky130_fd_sc_hd__fill_2
XFILLER_0_11_57 VPWR VGND VPWR VGND sky130_ef_sc_hd__decap_12
X_1400_ clknet_4_14_0_clk _0065_ VGND VGND VPWR VPWR net161 sky130_fd_sc_hd__dfxtp_1
X_1331_ _0250_ _0251_ _0415_ VGND VGND VPWR VPWR _0174_ sky130_fd_sc_hd__o21ba_1
Xinput6 i_dbus_rdt[13] VGND VGND VPWR VPWR net6 sky130_fd_sc_hd__buf_1
X_1262_ _0208_ VGND VGND VPWR VPWR _0148_ sky130_fd_sc_hd__clkbuf_1
X_1193_ _0448_ net54 _0636_ cpu.immdec.gen_immdec_w_eq_1.imm30_25\[4\] _0644_ VGND
+ VGND VPWR VPWR _0121_ sky130_fd_sc_hd__o221a_1
XFILLER_0_6_301 VGND VGND VPWR VPWR sky130_fd_sc_hd__decap_6
X_0977_ _0515_ net35 VGND VGND VPWR VPWR _0518_ sky130_fd_sc_hd__and2_1
XFILLER_0_45_281 VPWR VGND VPWR VGND sky130_ef_sc_hd__decap_12
XFILLER_0_9_161 VGND VGND VPWR VPWR sky130_fd_sc_hd__decap_6
XPHY_90 VGND VGND VPWR VPWR sky130_fd_sc_hd__decap_3
XFILLER_0_28_237 VGND VGND VPWR VPWR sky130_fd_sc_hd__fill_2
XFILLER_0_22_67 VGND VGND VPWR VPWR sky130_fd_sc_hd__fill_1
X_0900_ _0435_ _0436_ _0444_ _0452_ VGND VGND VPWR VPWR _0461_ sky130_fd_sc_hd__o211a_2
XFILLER_0_51_273 VGND VGND VPWR VPWR sky130_fd_sc_hd__decap_6
XFILLER_0_36_270 VGND VGND VPWR VPWR sky130_fd_sc_hd__fill_1
X_0762_ _0326_ _0340_ VGND VGND VPWR VPWR _0344_ sky130_fd_sc_hd__nor2_1
X_0831_ cpu.alu.i_rs1 cpu.bufreg.c_r _0403_ VGND VGND VPWR VPWR _0404_ sky130_fd_sc_hd__and3_1
X_0693_ cpu.immdec.gen_immdec_w_eq_1.imm11_7\[0\] net189 _0281_ VGND VGND VPWR VPWR
+ net184 sky130_fd_sc_hd__o21a_1
XFILLER_0_47_53 VGND VGND VPWR VPWR sky130_fd_sc_hd__decap_3
X_1314_ _0415_ _0314_ _0242_ VGND VGND VPWR VPWR _0243_ sky130_fd_sc_hd__and3b_1
X_1245_ _0196_ net27 _0579_ VGND VGND VPWR VPWR _0197_ sky130_fd_sc_hd__mux2_1
XFILLER_0_2_77 VGND VGND VPWR VPWR sky130_fd_sc_hd__decap_4
X_1176_ cpu.immdec.gen_immdec_w_eq_1.imm7 net193 _0420_ VGND VGND VPWR VPWR _0633_
+ sky130_fd_sc_hd__a21o_1
XFILLER_0_19_259 VGND VGND VPWR VPWR sky130_fd_sc_hd__decap_8
Xoutput173 net173 VGND VGND VPWR VPWR o_raddr[3] sky130_fd_sc_hd__clkbuf_4
Xoutput162 net162 VGND VGND VPWR VPWR o_ibus_adr[3] sky130_fd_sc_hd__clkbuf_4
Xoutput184 net184 VGND VGND VPWR VPWR o_waddr[4] sky130_fd_sc_hd__clkbuf_4
Xoutput140 net140 VGND VGND VPWR VPWR o_ibus_adr[12] sky130_fd_sc_hd__clkbuf_4
Xoutput151 net151 VGND VGND VPWR VPWR o_ibus_adr[22] sky130_fd_sc_hd__buf_2
XFILLER_0_10_181 VGND VGND VPWR VPWR sky130_fd_sc_hd__decap_8
XFILLER_0_33_251 VPWR VGND VPWR VGND sky130_ef_sc_hd__decap_12
XFILLER_0_18_281 VPWR VGND VPWR VGND sky130_ef_sc_hd__decap_12
X_1030_ net94 net95 _0342_ VGND VGND VPWR VPWR _0534_ sky130_fd_sc_hd__mux2_1
XFILLER_0_17_78 VGND VGND VPWR VPWR sky130_fd_sc_hd__fill_1
X_0814_ _0272_ _0394_ VGND VGND VPWR VPWR _0395_ sky130_fd_sc_hd__and2_1
Xinput20 i_dbus_rdt[26] VGND VGND VPWR VPWR net20 sky130_fd_sc_hd__buf_1
Xinput31 i_dbus_rdt[7] VGND VGND VPWR VPWR net31 sky130_fd_sc_hd__clkbuf_1
X_0676_ _0271_ VGND VGND VPWR VPWR net174 sky130_fd_sc_hd__clkbuf_1
Xinput64 i_ibus_rdt[9] VGND VGND VPWR VPWR net64 sky130_fd_sc_hd__clkbuf_1
Xinput53 i_ibus_rdt[28] VGND VGND VPWR VPWR net53 sky130_fd_sc_hd__buf_1
Xinput42 i_ibus_rdt[17] VGND VGND VPWR VPWR net42 sky130_fd_sc_hd__buf_1
X_0745_ cpu.decode.opcode\[0\] cpu.decode.opcode\[1\] cpu.decode.opcode\[2\] net136
+ VGND VGND VPWR VPWR _0327_ sky130_fd_sc_hd__or4b_1
XFILLER_0_28_3 VGND VGND VPWR VPWR sky130_fd_sc_hd__fill_2
X_1228_ _0388_ net59 _0515_ VGND VGND VPWR VPWR _0186_ sky130_fd_sc_hd__mux2_1
X_1159_ _0620_ VGND VGND VPWR VPWR _0111_ sky130_fd_sc_hd__clkbuf_1
XFILLER_0_30_221 VGND VGND VPWR VPWR sky130_fd_sc_hd__decap_8
XTAP_405 VGND VPWR sky130_fd_sc_hd__tapvpwrvgnd_1
XFILLER_0_0_104 VGND VGND VPWR VPWR sky130_fd_sc_hd__decap_4
XFILLER_0_0_126 VGND VGND VPWR VPWR sky130_fd_sc_hd__fill_1
XFILLER_0_21_210 VGND VGND VPWR VPWR sky130_fd_sc_hd__fill_2
XFILLER_0_21_254 VGND VGND VPWR VPWR sky130_fd_sc_hd__decap_6
XFILLER_0_28_33 VGND VGND VPWR VPWR sky130_fd_sc_hd__fill_1
XFILLER_0_28_11 VGND VGND VPWR VPWR sky130_fd_sc_hd__decap_4
XFILLER_0_44_32 VGND VGND VPWR VPWR sky130_fd_sc_hd__decap_8
XFILLER_0_44_21 VGND VGND VPWR VPWR sky130_fd_sc_hd__decap_6
X_1013_ net153 _0526_ _0527_ net154 VGND VGND VPWR VPWR _0058_ sky130_fd_sc_hd__a22o_1
XFILLER_0_12_221 VGND VGND VPWR VPWR sky130_fd_sc_hd__decap_3
X_0728_ cpu.state.cnt_r\[3\] VGND VGND VPWR VPWR _0310_ sky130_fd_sc_hd__clkbuf_4
X_0659_ _0254_ cpu.decode.op26 VGND VGND VPWR VPWR _0255_ sky130_fd_sc_hd__and2_1
XFILLER_0_12_265 VPWR VGND VPWR VGND sky130_ef_sc_hd__decap_12
XFILLER_0_35_302 VGND VGND VPWR VPWR sky130_fd_sc_hd__decap_8
Xclkbuf_4_8_0_clk clknet_0_clk VGND VGND VPWR VPWR clknet_4_8_0_clk sky130_fd_sc_hd__clkbuf_8
XFILLER_0_7_281 VPWR VGND VPWR VGND sky130_ef_sc_hd__decap_12
XFILLER_0_14_46 VGND VGND VPWR VPWR sky130_fd_sc_hd__fill_2
XFILLER_0_38_195 VGND VGND VPWR VPWR sky130_fd_sc_hd__fill_1
XFILLER_0_38_173 VPWR VGND VPWR VGND sky130_ef_sc_hd__decap_12
XFILLER_0_26_302 VGND VGND VPWR VPWR sky130_fd_sc_hd__decap_6
X_1493_ clknet_4_6_0_clk _0155_ VGND VGND VPWR VPWR net106 sky130_fd_sc_hd__dfxtp_1
XTAP_202 VGND VPWR sky130_fd_sc_hd__tapvpwrvgnd_1
XTAP_213 VGND VPWR sky130_fd_sc_hd__tapvpwrvgnd_1
XTAP_224 VGND VPWR sky130_fd_sc_hd__tapvpwrvgnd_1
XTAP_235 VGND VPWR sky130_fd_sc_hd__tapvpwrvgnd_1
XTAP_246 VGND VPWR sky130_fd_sc_hd__tapvpwrvgnd_1
XTAP_257 VGND VPWR sky130_fd_sc_hd__tapvpwrvgnd_1
XTAP_279 VGND VPWR sky130_fd_sc_hd__tapvpwrvgnd_1
XTAP_268 VGND VPWR sky130_fd_sc_hd__tapvpwrvgnd_1
XFILLER_0_12_6 VGND VGND VPWR VPWR sky130_fd_sc_hd__fill_1
XFILLER_0_44_165 VGND VGND VPWR VPWR sky130_fd_sc_hd__decap_6
XFILLER_0_4_240 VPWR VGND VPWR VGND sky130_ef_sc_hd__decap_12
XFILLER_0_25_78 VPWR VGND VPWR VGND sky130_ef_sc_hd__decap_12
X_0993_ net167 _0520_ _0523_ net168 VGND VGND VPWR VPWR _0042_ sky130_fd_sc_hd__a22o_1
X_1476_ clknet_4_5_0_clk _0138_ VGND VGND VPWR VPWR net136 sky130_fd_sc_hd__dfxtp_4
XFILLER_0_5_88 VGND VGND VPWR VPWR sky130_fd_sc_hd__fill_2
XFILLER_0_5_66 VGND VGND VPWR VPWR sky130_fd_sc_hd__decap_6
XFILLER_0_5_55 VGND VGND VPWR VPWR sky130_fd_sc_hd__fill_1
XFILLER_0_10_3 VGND VGND VPWR VPWR sky130_fd_sc_hd__fill_2
XFILLER_0_49_279 VGND VGND VPWR VPWR sky130_fd_sc_hd__fill_1
XFILLER_0_11_69 VGND VGND VPWR VPWR sky130_fd_sc_hd__decap_3
XFILLER_0_23_113 VGND VGND VPWR VPWR sky130_fd_sc_hd__decap_6
X_1261_ _0207_ net32 _0203_ VGND VGND VPWR VPWR _0208_ sky130_fd_sc_hd__mux2_1
X_1330_ _0289_ _0433_ _0439_ _0288_ VGND VGND VPWR VPWR _0251_ sky130_fd_sc_hd__o211a_1
Xinput7 i_dbus_rdt[14] VGND VGND VPWR VPWR net7 sky130_fd_sc_hd__clkbuf_1
X_1192_ _0419_ cpu.immdec.gen_immdec_w_eq_1.imm30_25\[5\] _0636_ VGND VGND VPWR VPWR
+ _0644_ sky130_fd_sc_hd__or3b_1
XFILLER_0_52_76 VGND VGND VPWR VPWR sky130_fd_sc_hd__decap_8
X_0976_ cpu.immdec.gen_immdec_w_eq_1.imm11_7\[2\] _0512_ _0514_ cpu.immdec.gen_immdec_w_eq_1.imm11_7\[3\]
+ _0517_ VGND VGND VPWR VPWR _0031_ sky130_fd_sc_hd__a221o_1
X_1459_ clknet_4_11_0_clk _0121_ VGND VGND VPWR VPWR cpu.immdec.gen_immdec_w_eq_1.imm30_25\[4\]
+ sky130_fd_sc_hd__dfxtp_1
XFILLER_0_52_219 VGND VGND VPWR VPWR sky130_fd_sc_hd__decap_4
XFILLER_0_45_293 VPWR VGND VPWR VGND sky130_ef_sc_hd__decap_12
XPHY_91 VGND VGND VPWR VPWR sky130_fd_sc_hd__decap_3
XPHY_80 VGND VGND VPWR VPWR sky130_fd_sc_hd__decap_3
X_0830_ _0307_ cpu.decode.opcode\[1\] cpu.branch_op VGND VGND VPWR VPWR _0403_ sky130_fd_sc_hd__o21ai_1
X_0692_ _0255_ _0266_ _0276_ VGND VGND VPWR VPWR _0281_ sky130_fd_sc_hd__o21ai_1
X_0761_ cpu.bufreg.data\[0\] _0342_ _0288_ VGND VGND VPWR VPWR _0343_ sky130_fd_sc_hd__a21o_1
X_1244_ net125 net126 _0189_ VGND VGND VPWR VPWR _0196_ sky130_fd_sc_hd__mux2_1
XFILLER_0_47_98 VGND VGND VPWR VPWR sky130_fd_sc_hd__decap_3
XFILLER_0_47_21 VPWR VGND VPWR VGND sky130_ef_sc_hd__decap_12
XFILLER_0_44_9 VPWR VGND VPWR VGND sky130_ef_sc_hd__decap_12
X_1313_ _0310_ _0312_ _0332_ _0311_ VGND VGND VPWR VPWR _0242_ sky130_fd_sc_hd__a31o_1
XFILLER_0_2_12 VGND VGND VPWR VPWR sky130_fd_sc_hd__fill_1
X_1175_ net193 _0627_ VGND VGND VPWR VPWR _0632_ sky130_fd_sc_hd__nor2_1
X_0959_ cpu.gen_csr.csr.mcause3_0\[1\] _0505_ _0503_ VGND VGND VPWR VPWR _0506_ sky130_fd_sc_hd__mux2_1
XFILLER_0_6_154 VPWR VGND VPWR VGND sky130_ef_sc_hd__decap_12
Xoutput152 net152 VGND VGND VPWR VPWR o_ibus_adr[23] sky130_fd_sc_hd__clkbuf_4
Xoutput185 net185 VGND VGND VPWR VPWR o_waddr[5] sky130_fd_sc_hd__clkbuf_4
Xoutput174 net174 VGND VGND VPWR VPWR o_raddr[4] sky130_fd_sc_hd__clkbuf_4
Xoutput141 net141 VGND VGND VPWR VPWR o_ibus_adr[13] sky130_fd_sc_hd__buf_2
Xoutput163 net163 VGND VGND VPWR VPWR o_ibus_adr[4] sky130_fd_sc_hd__clkbuf_4
Xoutput130 net130 VGND VGND VPWR VPWR o_dbus_dat[8] sky130_fd_sc_hd__clkbuf_4
XFILLER_0_10_171 VGND VGND VPWR VPWR sky130_fd_sc_hd__fill_1
XFILLER_0_33_263 VPWR VGND VPWR VGND sky130_ef_sc_hd__decap_12
XFILLER_0_18_293 VGND VGND VPWR VPWR sky130_fd_sc_hd__fill_1
XFILLER_0_17_68 VGND VGND VPWR VPWR sky130_fd_sc_hd__decap_6
Xinput10 i_dbus_rdt[17] VGND VGND VPWR VPWR net10 sky130_fd_sc_hd__clkbuf_1
Xinput21 i_dbus_rdt[27] VGND VGND VPWR VPWR net21 sky130_fd_sc_hd__buf_1
Xinput54 i_ibus_rdt[29] VGND VGND VPWR VPWR net54 sky130_fd_sc_hd__buf_1
XFILLER_0_3_113 VPWR VGND VPWR VGND sky130_ef_sc_hd__decap_12
Xinput32 i_dbus_rdt[8] VGND VGND VPWR VPWR net32 sky130_fd_sc_hd__buf_1
Xinput43 i_ibus_rdt[18] VGND VGND VPWR VPWR net43 sky130_fd_sc_hd__dlymetal6s2s_1
X_0813_ _0257_ _0391_ _0392_ _0393_ _0367_ VGND VGND VPWR VPWR _0394_ sky130_fd_sc_hd__a32o_1
X_0675_ cpu.csr_imm _0270_ _0252_ VGND VGND VPWR VPWR _0271_ sky130_fd_sc_hd__mux2_1
X_0744_ _0260_ _0325_ VGND VGND VPWR VPWR _0326_ sky130_fd_sc_hd__or2_1
Xinput65 i_rdata[0] VGND VGND VPWR VPWR net65 sky130_fd_sc_hd__buf_1
X_1158_ _0619_ cpu.csr_imm _0610_ VGND VGND VPWR VPWR _0620_ sky130_fd_sc_hd__mux2_1
XFILLER_0_42_6 VPWR VGND VPWR VGND sky130_ef_sc_hd__decap_12
X_1227_ _0185_ VGND VGND VPWR VPWR _0136_ sky130_fd_sc_hd__clkbuf_1
X_1089_ net117 _0564_ _0565_ VGND VGND VPWR VPWR _0566_ sky130_fd_sc_hd__mux2_1
XTAP_406 VGND VPWR sky130_fd_sc_hd__tapvpwrvgnd_1
XFILLER_0_28_23 VGND VGND VPWR VPWR sky130_fd_sc_hd__decap_4
X_1012_ net152 _0526_ _0527_ net153 VGND VGND VPWR VPWR _0057_ sky130_fd_sc_hd__a22o_1
XFILLER_0_12_233 VGND VGND VPWR VPWR sky130_fd_sc_hd__decap_8
X_0727_ cpu.bufreg.i_right_shift_op VGND VGND VPWR VPWR _0309_ sky130_fd_sc_hd__inv_2
X_0658_ cpu.decode.op21 VGND VGND VPWR VPWR _0254_ sky130_fd_sc_hd__inv_2
XFILLER_0_12_277 VPWR VGND VPWR VGND sky130_ef_sc_hd__decap_12
XFILLER_0_47_130 VGND VGND VPWR VPWR sky130_fd_sc_hd__decap_4
XFILLER_0_7_293 VPWR VGND VPWR VGND sky130_ef_sc_hd__decap_12
XFILLER_0_38_141 VGND VGND VPWR VPWR sky130_fd_sc_hd__fill_2
XFILLER_0_38_185 VGND VGND VPWR VPWR sky130_fd_sc_hd__decap_3
XFILLER_0_30_79 VGND VGND VPWR VPWR sky130_fd_sc_hd__decap_4
XFILLER_0_5_219 VGND VGND VPWR VPWR sky130_fd_sc_hd__fill_2
X_1492_ clknet_4_7_0_clk _0154_ VGND VGND VPWR VPWR net105 sky130_fd_sc_hd__dfxtp_2
XTAP_269 VGND VPWR sky130_fd_sc_hd__tapvpwrvgnd_1
XTAP_203 VGND VPWR sky130_fd_sc_hd__tapvpwrvgnd_1
XTAP_214 VGND VPWR sky130_fd_sc_hd__tapvpwrvgnd_1
XTAP_225 VGND VPWR sky130_fd_sc_hd__tapvpwrvgnd_1
XTAP_236 VGND VPWR sky130_fd_sc_hd__tapvpwrvgnd_1
XTAP_247 VGND VPWR sky130_fd_sc_hd__tapvpwrvgnd_1
XTAP_258 VGND VPWR sky130_fd_sc_hd__tapvpwrvgnd_1
XFILLER_0_35_122 VPWR VGND VPWR VGND sky130_ef_sc_hd__decap_12
XFILLER_0_25_13 VGND VGND VPWR VPWR sky130_fd_sc_hd__fill_1
XFILLER_0_41_78 VPWR VGND VPWR VGND sky130_ef_sc_hd__decap_12
X_0992_ net166 _0520_ _0523_ net167 VGND VGND VPWR VPWR _0041_ sky130_fd_sc_hd__a22o_1
XFILLER_0_26_100 VGND VGND VPWR VPWR sky130_fd_sc_hd__decap_4
XFILLER_0_14_306 VGND VGND VPWR VPWR sky130_fd_sc_hd__fill_2
XFILLER_0_26_177 VGND VGND VPWR VPWR sky130_fd_sc_hd__decap_3
Xclkbuf_4_7_0_clk clknet_0_clk VGND VGND VPWR VPWR clknet_4_7_0_clk sky130_fd_sc_hd__clkbuf_8
X_1475_ clknet_4_1_0_clk _0137_ VGND VGND VPWR VPWR cpu.decode.opcode\[2\] sky130_fd_sc_hd__dfxtp_2
XFILLER_0_49_225 VPWR VGND VPWR VGND sky130_ef_sc_hd__decap_12
XFILLER_0_49_214 VGND VGND VPWR VPWR sky130_fd_sc_hd__fill_1
XFILLER_0_17_100 VGND VGND VPWR VPWR sky130_fd_sc_hd__fill_2
XFILLER_0_20_309 VGND VGND VPWR VPWR sky130_fd_sc_hd__fill_1
Xinput8 i_dbus_rdt[15] VGND VGND VPWR VPWR net8 sky130_fd_sc_hd__buf_1
X_1191_ _0643_ VGND VGND VPWR VPWR _0120_ sky130_fd_sc_hd__clkbuf_1
X_1260_ net130 net131 _0189_ VGND VGND VPWR VPWR _0207_ sky130_fd_sc_hd__mux2_1
XFILLER_0_52_55 VGND VGND VPWR VPWR sky130_fd_sc_hd__fill_1
XFILLER_0_52_44 VGND VGND VPWR VPWR sky130_fd_sc_hd__fill_1
X_0975_ _0515_ net64 VGND VGND VPWR VPWR _0517_ sky130_fd_sc_hd__and2_1
X_1458_ clknet_4_10_0_clk _0120_ VGND VGND VPWR VPWR cpu.immdec.gen_immdec_w_eq_1.imm30_25\[3\]
+ sky130_fd_sc_hd__dfxtp_1
X_1389_ clknet_4_10_0_clk _0054_ VGND VGND VPWR VPWR net149 sky130_fd_sc_hd__dfxtp_1
XFILLER_0_45_261 VGND VGND VPWR VPWR sky130_fd_sc_hd__decap_4
XFILLER_0_20_139 VGND VGND VPWR VPWR sky130_fd_sc_hd__fill_1
XFILLER_0_51_220 VGND VGND VPWR VPWR sky130_fd_sc_hd__decap_4
XPHY_92 VGND VGND VPWR VPWR sky130_fd_sc_hd__decap_3
XPHY_81 VGND VGND VPWR VPWR sky130_fd_sc_hd__decap_3
XPHY_70 VGND VGND VPWR VPWR sky130_fd_sc_hd__decap_3
XFILLER_0_28_228 VGND VGND VPWR VPWR sky130_fd_sc_hd__decap_3
X_0760_ _0324_ VGND VGND VPWR VPWR _0342_ sky130_fd_sc_hd__clkbuf_4
X_0691_ _0280_ VGND VGND VPWR VPWR net189 sky130_fd_sc_hd__inv_2
XFILLER_0_47_33 VPWR VGND VPWR VGND sky130_ef_sc_hd__decap_12
X_1243_ _0195_ VGND VGND VPWR VPWR _0142_ sky130_fd_sc_hd__clkbuf_1
X_1312_ _0493_ _0492_ _0241_ VGND VGND VPWR VPWR _0165_ sky130_fd_sc_hd__a21oi_1
X_1174_ _0631_ VGND VGND VPWR VPWR _0115_ sky130_fd_sc_hd__clkbuf_1
XFILLER_0_42_253 VGND VGND VPWR VPWR sky130_fd_sc_hd__decap_8
X_0958_ _0290_ net136 _0501_ cpu.gen_csr.csr.mcause3_0\[2\] _0264_ VGND VGND VPWR
+ VPWR _0505_ sky130_fd_sc_hd__a221o_1
X_0889_ net67 net34 VGND VGND VPWR VPWR _0452_ sky130_fd_sc_hd__nor2_1
XFILLER_0_6_166 VGND VGND VPWR VPWR sky130_fd_sc_hd__decap_4
Xoutput186 net186 VGND VGND VPWR VPWR o_waddr[6] sky130_fd_sc_hd__clkbuf_4
Xoutput131 net131 VGND VGND VPWR VPWR o_dbus_dat[9] sky130_fd_sc_hd__buf_2
Xoutput153 net153 VGND VGND VPWR VPWR o_ibus_adr[24] sky130_fd_sc_hd__buf_2
Xoutput120 net120 VGND VGND VPWR VPWR o_dbus_dat[28] sky130_fd_sc_hd__clkbuf_4
Xoutput175 net175 VGND VGND VPWR VPWR o_raddr[5] sky130_fd_sc_hd__clkbuf_4
Xoutput164 net164 VGND VGND VPWR VPWR o_ibus_adr[5] sky130_fd_sc_hd__clkbuf_4
XFILLER_0_10_150 VGND VGND VPWR VPWR sky130_fd_sc_hd__fill_1
Xoutput142 net142 VGND VGND VPWR VPWR o_ibus_adr[14] sky130_fd_sc_hd__clkbuf_4
XFILLER_0_33_275 VGND VGND VPWR VPWR sky130_fd_sc_hd__fill_2
XFILLER_0_0_309 VGND VGND VPWR VPWR sky130_fd_sc_hd__decap_4
Xinput66 i_rdata[1] VGND VGND VPWR VPWR net66 sky130_fd_sc_hd__buf_1
Xinput22 i_dbus_rdt[28] VGND VGND VPWR VPWR net22 sky130_fd_sc_hd__dlymetal6s2s_1
Xinput33 i_dbus_rdt[9] VGND VGND VPWR VPWR net33 sky130_fd_sc_hd__clkbuf_1
X_0743_ _0290_ _0289_ VGND VGND VPWR VPWR _0325_ sky130_fd_sc_hd__nand2_1
Xinput11 i_dbus_rdt[18] VGND VGND VPWR VPWR net11 sky130_fd_sc_hd__clkbuf_1
XFILLER_0_3_125 VPWR VGND VPWR VGND sky130_ef_sc_hd__decap_12
Xinput55 i_ibus_rdt[2] VGND VGND VPWR VPWR net55 sky130_fd_sc_hd__clkbuf_1
Xinput44 i_ibus_rdt[19] VGND VGND VPWR VPWR net44 sky130_fd_sc_hd__buf_1
X_0812_ _0316_ _0391_ cpu.bne_or_bge VGND VGND VPWR VPWR _0393_ sky130_fd_sc_hd__o21ai_1
XFILLER_0_24_231 VGND VGND VPWR VPWR sky130_fd_sc_hd__fill_1
XFILLER_0_24_242 VGND VGND VPWR VPWR sky130_fd_sc_hd__fill_1
X_0674_ _0256_ _0263_ _0269_ cpu.immdec.gen_immdec_w_eq_1.imm24_20\[0\] _0266_ VGND
+ VGND VPWR VPWR _0270_ sky130_fd_sc_hd__a221o_1
X_1157_ cpu.immdec.gen_immdec_w_eq_1.imm19_12_20\[5\] net40 _0614_ VGND VGND VPWR
+ VPWR _0619_ sky130_fd_sc_hd__mux2_1
X_1226_ cpu.decode.opcode\[1\] net58 _0515_ VGND VGND VPWR VPWR _0185_ sky130_fd_sc_hd__mux2_1
X_1088_ _0317_ VGND VGND VPWR VPWR _0565_ sky130_fd_sc_hd__buf_2
XFILLER_0_38_312 VGND VGND VPWR VPWR sky130_fd_sc_hd__fill_2
XTAP_407 VGND VPWR sky130_fd_sc_hd__tapvpwrvgnd_1
XFILLER_0_21_223 VGND VGND VPWR VPWR sky130_fd_sc_hd__fill_1
X_1011_ net151 _0526_ _0527_ net152 VGND VGND VPWR VPWR _0056_ sky130_fd_sc_hd__a22o_1
XFILLER_0_8_89 VGND VGND VPWR VPWR sky130_fd_sc_hd__fill_1
X_0726_ _0305_ _0306_ _0259_ _0307_ VGND VGND VPWR VPWR _0308_ sky130_fd_sc_hd__o211ai_1
XFILLER_0_12_289 VPWR VGND VPWR VGND sky130_ef_sc_hd__decap_12
X_0657_ _0253_ VGND VGND VPWR VPWR _0000_ sky130_fd_sc_hd__clkbuf_1
X_1209_ net48 _0177_ _0448_ VGND VGND VPWR VPWR _0178_ sky130_fd_sc_hd__mux2_1
XFILLER_0_47_164 VGND VGND VPWR VPWR sky130_fd_sc_hd__decap_4
XFILLER_0_7_261 VPWR VGND VPWR VGND sky130_ef_sc_hd__decap_12
XFILLER_0_38_197 VGND VGND VPWR VPWR sky130_fd_sc_hd__fill_1
XFILLER_0_39_12 VGND VGND VPWR VPWR sky130_fd_sc_hd__decap_8
XFILLER_0_30_25 VGND VGND VPWR VPWR sky130_fd_sc_hd__decap_3
X_1491_ clknet_4_15_0_clk _0153_ VGND VGND VPWR VPWR net104 sky130_fd_sc_hd__dfxtp_1
XTAP_259 VGND VPWR sky130_fd_sc_hd__tapvpwrvgnd_1
XTAP_204 VGND VPWR sky130_fd_sc_hd__tapvpwrvgnd_1
XTAP_215 VGND VPWR sky130_fd_sc_hd__tapvpwrvgnd_1
XTAP_226 VGND VPWR sky130_fd_sc_hd__tapvpwrvgnd_1
XTAP_237 VGND VPWR sky130_fd_sc_hd__tapvpwrvgnd_1
XTAP_248 VGND VPWR sky130_fd_sc_hd__tapvpwrvgnd_1
X_0709_ _0290_ net136 VGND VGND VPWR VPWR _0291_ sky130_fd_sc_hd__nand2_1
XFILLER_0_4_253 VPWR VGND VPWR VGND sky130_ef_sc_hd__decap_12
XFILLER_0_35_167 VGND VGND VPWR VPWR sky130_fd_sc_hd__fill_1
XFILLER_0_35_134 VGND VGND VPWR VPWR sky130_fd_sc_hd__fill_1
XFILLER_0_41_57 VGND VGND VPWR VPWR sky130_fd_sc_hd__decap_8
X_0991_ net165 _0520_ _0523_ net166 VGND VGND VPWR VPWR _0040_ sky130_fd_sc_hd__a22o_1
XFILLER_0_26_156 VPWR VGND VPWR VGND sky130_ef_sc_hd__decap_12
XFILLER_0_5_24 VGND VGND VPWR VPWR sky130_fd_sc_hd__decap_8
XFILLER_0_1_289 VGND VGND VPWR VPWR sky130_fd_sc_hd__fill_2
X_1474_ clknet_4_1_0_clk _0136_ VGND VGND VPWR VPWR cpu.decode.opcode\[1\] sky130_fd_sc_hd__dfxtp_2
XFILLER_0_49_237 VPWR VGND VPWR VGND sky130_ef_sc_hd__decap_12
XFILLER_0_17_123 VGND VGND VPWR VPWR sky130_fd_sc_hd__fill_2
XFILLER_0_17_167 VGND VGND VPWR VPWR sky130_fd_sc_hd__fill_1
Xinput9 i_dbus_rdt[16] VGND VGND VPWR VPWR net9 sky130_fd_sc_hd__clkbuf_1
X_1190_ cpu.immdec.gen_immdec_w_eq_1.imm30_25\[3\] _0642_ _0636_ VGND VGND VPWR VPWR
+ _0643_ sky130_fd_sc_hd__mux2_1
X_0974_ cpu.immdec.gen_immdec_w_eq_1.imm11_7\[1\] _0512_ _0514_ net205 _0516_ VGND
+ VGND VPWR VPWR _0030_ sky130_fd_sc_hd__a221o_1
X_1457_ clknet_4_8_0_clk _0119_ VGND VGND VPWR VPWR cpu.immdec.gen_immdec_w_eq_1.imm30_25\[2\]
+ sky130_fd_sc_hd__dfxtp_1
X_1388_ clknet_4_0_0_clk _0053_ VGND VGND VPWR VPWR net147 sky130_fd_sc_hd__dfxtp_1
XFILLER_0_13_192 VGND VGND VPWR VPWR sky130_fd_sc_hd__decap_8
XPHY_82 VGND VGND VPWR VPWR sky130_fd_sc_hd__decap_3
XPHY_71 VGND VGND VPWR VPWR sky130_fd_sc_hd__decap_3
XPHY_60 VGND VGND VPWR VPWR sky130_fd_sc_hd__decap_3
XPHY_93 VGND VGND VPWR VPWR sky130_fd_sc_hd__decap_3
Xclkbuf_4_6_0_clk clknet_0_clk VGND VGND VPWR VPWR clknet_4_6_0_clk sky130_fd_sc_hd__clkbuf_8
X_0690_ rf_ram_if.rtrig0 _0266_ VGND VGND VPWR VPWR _0280_ sky130_fd_sc_hd__nor2_1
XFILLER_0_47_45 VGND VGND VPWR VPWR sky130_fd_sc_hd__decap_8
X_1311_ _0310_ _0312_ _0332_ net67 VGND VGND VPWR VPWR _0241_ sky130_fd_sc_hd__a31o_1
XFILLER_0_11_129 VGND VGND VPWR VPWR sky130_fd_sc_hd__fill_1
X_1242_ _0194_ net24 _0579_ VGND VGND VPWR VPWR _0195_ sky130_fd_sc_hd__mux2_1
X_1173_ _0630_ cpu.immdec.gen_immdec_w_eq_1.imm19_12_20\[8\] _0610_ VGND VGND VPWR
+ VPWR _0631_ sky130_fd_sc_hd__mux2_1
XFILLER_0_19_218 VGND VGND VPWR VPWR sky130_fd_sc_hd__decap_6
Xoutput132 net132 VGND VGND VPWR VPWR o_dbus_sel[0] sky130_fd_sc_hd__clkbuf_4
X_0957_ _0504_ VGND VGND VPWR VPWR _0025_ sky130_fd_sc_hd__clkbuf_1
Xoutput110 net110 VGND VGND VPWR VPWR o_dbus_dat[19] sky130_fd_sc_hd__buf_2
Xoutput121 net121 VGND VGND VPWR VPWR o_dbus_dat[29] sky130_fd_sc_hd__clkbuf_4
Xoutput143 net143 VGND VGND VPWR VPWR o_ibus_adr[15] sky130_fd_sc_hd__clkbuf_4
X_0888_ _0451_ VGND VGND VPWR VPWR _0009_ sky130_fd_sc_hd__clkbuf_1
Xoutput176 net176 VGND VGND VPWR VPWR o_raddr[6] sky130_fd_sc_hd__clkbuf_4
Xoutput187 net187 VGND VGND VPWR VPWR o_waddr[7] sky130_fd_sc_hd__clkbuf_4
X_1509_ clknet_4_5_0_clk _0171_ VGND VGND VPWR VPWR cpu.state.cnt_r\[2\] sky130_fd_sc_hd__dfxtp_1
Xoutput154 net154 VGND VGND VPWR VPWR o_ibus_adr[25] sky130_fd_sc_hd__clkbuf_4
Xoutput165 net165 VGND VGND VPWR VPWR o_ibus_adr[6] sky130_fd_sc_hd__clkbuf_4
XFILLER_0_10_195 VGND VGND VPWR VPWR sky130_fd_sc_hd__fill_1
XFILLER_0_33_287 VGND VGND VPWR VPWR sky130_fd_sc_hd__fill_2
Xinput34 i_ibus_ack VGND VGND VPWR VPWR net34 sky130_fd_sc_hd__buf_2
Xinput67 i_rst VGND VGND VPWR VPWR net67 sky130_fd_sc_hd__clkbuf_4
Xinput12 i_dbus_rdt[19] VGND VGND VPWR VPWR net12 sky130_fd_sc_hd__buf_1
X_0673_ _0263_ _0268_ VGND VGND VPWR VPWR _0269_ sky130_fd_sc_hd__nor2_1
XFILLER_0_3_137 VPWR VGND VPWR VGND sky130_ef_sc_hd__decap_12
Xinput23 i_dbus_rdt[29] VGND VGND VPWR VPWR net23 sky130_fd_sc_hd__buf_1
Xinput56 i_ibus_rdt[30] VGND VGND VPWR VPWR net56 sky130_fd_sc_hd__buf_1
X_0811_ cpu.bne_or_bge _0298_ VGND VGND VPWR VPWR _0392_ sky130_fd_sc_hd__nand2_1
X_0742_ cpu.state.init_done _0299_ _0319_ _0323_ VGND VGND VPWR VPWR _0324_ sky130_fd_sc_hd__a31o_4
Xinput45 i_ibus_rdt[20] VGND VGND VPWR VPWR net45 sky130_fd_sc_hd__buf_1
X_1156_ _0618_ VGND VGND VPWR VPWR _0110_ sky130_fd_sc_hd__clkbuf_1
X_1087_ net116 VGND VGND VPWR VPWR _0564_ sky130_fd_sc_hd__inv_2
X_1225_ _0184_ VGND VGND VPWR VPWR _0135_ sky130_fd_sc_hd__clkbuf_1
XFILLER_0_2_181 VPWR VGND VPWR VGND sky130_ef_sc_hd__decap_12
XFILLER_0_21_202 VGND VGND VPWR VPWR sky130_fd_sc_hd__decap_8
XFILLER_0_21_279 VGND VGND VPWR VPWR sky130_fd_sc_hd__fill_1
X_1010_ net150 _0526_ _0527_ net151 VGND VGND VPWR VPWR _0055_ sky130_fd_sc_hd__a22o_1
XFILLER_0_12_213 VGND VGND VPWR VPWR sky130_fd_sc_hd__decap_8
X_0656_ rf_ram_if.rdata0\[1\] net65 _0252_ VGND VGND VPWR VPWR _0253_ sky130_fd_sc_hd__mux2_1
X_0725_ cpu.decode.opcode\[0\] VGND VGND VPWR VPWR _0307_ sky130_fd_sc_hd__inv_2
X_1208_ cpu.immdec.gen_immdec_w_eq_1.imm24_20\[3\] cpu.immdec.gen_immdec_w_eq_1.imm24_20\[4\]
+ _0650_ VGND VGND VPWR VPWR _0177_ sky130_fd_sc_hd__mux2_1
XFILLER_0_26_3 VGND VGND VPWR VPWR sky130_fd_sc_hd__fill_1
XFILLER_0_47_110 VGND VGND VPWR VPWR sky130_fd_sc_hd__fill_2
X_1139_ _0605_ VGND VGND VPWR VPWR _0106_ sky130_fd_sc_hd__clkbuf_1
XFILLER_0_7_273 VGND VGND VPWR VPWR sky130_fd_sc_hd__decap_6
XFILLER_0_14_27 VGND VGND VPWR VPWR sky130_fd_sc_hd__fill_1
XFILLER_0_14_38 VGND VGND VPWR VPWR sky130_fd_sc_hd__decap_8
X_1490_ clknet_4_15_0_clk _0152_ VGND VGND VPWR VPWR net103 sky130_fd_sc_hd__dfxtp_1
XFILLER_0_39_57 VGND VGND VPWR VPWR sky130_fd_sc_hd__decap_3
XFILLER_0_39_46 VGND VGND VPWR VPWR sky130_fd_sc_hd__fill_1
XTAP_205 VGND VPWR sky130_fd_sc_hd__tapvpwrvgnd_1
Xhold1 rf_ram_if.wdata1_r\[2\] VGND VGND VPWR VPWR net197 sky130_fd_sc_hd__dlygate4sd3_1
XTAP_216 VGND VPWR sky130_fd_sc_hd__tapvpwrvgnd_1
XTAP_227 VGND VPWR sky130_fd_sc_hd__tapvpwrvgnd_1
XTAP_238 VGND VPWR sky130_fd_sc_hd__tapvpwrvgnd_1
XTAP_249 VGND VPWR sky130_fd_sc_hd__tapvpwrvgnd_1
XFILLER_0_29_121 VPWR VGND VPWR VGND sky130_ef_sc_hd__decap_12
XFILLER_0_29_165 VGND VGND VPWR VPWR sky130_fd_sc_hd__decap_3
XFILLER_0_4_265 VPWR VGND VPWR VGND sky130_ef_sc_hd__decap_12
X_0708_ _0259_ VGND VGND VPWR VPWR _0290_ sky130_fd_sc_hd__clkbuf_4
XFILLER_0_35_113 VGND VGND VPWR VPWR sky130_fd_sc_hd__fill_1
XFILLER_0_0_91 VGND VGND VPWR VPWR sky130_fd_sc_hd__decap_3
XFILLER_0_23_308 VGND VGND VPWR VPWR sky130_fd_sc_hd__decap_6
X_0990_ net164 _0520_ _0523_ net165 VGND VGND VPWR VPWR _0039_ sky130_fd_sc_hd__a22o_1
XFILLER_0_26_168 VGND VGND VPWR VPWR sky130_fd_sc_hd__fill_1
XFILLER_0_1_279 VGND VGND VPWR VPWR sky130_fd_sc_hd__fill_1
X_1473_ clknet_4_2_0_clk _0135_ VGND VGND VPWR VPWR cpu.decode.opcode\[0\] sky130_fd_sc_hd__dfxtp_1
XFILLER_0_49_249 VPWR VGND VPWR VGND sky130_ef_sc_hd__decap_12
XFILLER_0_40_182 VPWR VGND VPWR VGND sky130_ef_sc_hd__decap_12
XFILLER_0_11_28 VGND VGND VPWR VPWR sky130_fd_sc_hd__decap_8
XFILLER_0_31_193 VPWR VGND VPWR VGND sky130_ef_sc_hd__decap_12
XFILLER_0_52_57 VGND VGND VPWR VPWR sky130_fd_sc_hd__fill_2
XFILLER_0_46_219 VGND VGND VPWR VPWR sky130_fd_sc_hd__decap_8
X_0973_ _0515_ net63 VGND VGND VPWR VPWR _0516_ sky130_fd_sc_hd__and2_1
XFILLER_0_14_138 VGND VGND VPWR VPWR sky130_fd_sc_hd__fill_2
X_1387_ clknet_4_0_0_clk _0052_ VGND VGND VPWR VPWR net146 sky130_fd_sc_hd__dfxtp_1
X_1456_ clknet_4_9_0_clk _0118_ VGND VGND VPWR VPWR cpu.immdec.gen_immdec_w_eq_1.imm30_25\[1\]
+ sky130_fd_sc_hd__dfxtp_1
XPHY_94 VGND VGND VPWR VPWR sky130_fd_sc_hd__decap_3
XPHY_83 VGND VGND VPWR VPWR sky130_fd_sc_hd__decap_3
XPHY_72 VGND VGND VPWR VPWR sky130_fd_sc_hd__decap_3
XPHY_61 VGND VGND VPWR VPWR sky130_fd_sc_hd__decap_3
XFILLER_0_28_219 VGND VGND VPWR VPWR sky130_fd_sc_hd__fill_2
XPHY_50 VGND VGND VPWR VPWR sky130_fd_sc_hd__decap_3
X_1241_ net122 net125 _0189_ VGND VGND VPWR VPWR _0194_ sky130_fd_sc_hd__mux2_1
XFILLER_0_47_57 VPWR VGND VPWR VGND sky130_ef_sc_hd__decap_12
X_1310_ _0415_ _0240_ VGND VGND VPWR VPWR _0164_ sky130_fd_sc_hd__nor2_1
X_1172_ _0419_ net44 _0628_ _0629_ VGND VGND VPWR VPWR _0630_ sky130_fd_sc_hd__a22o_1
X_0956_ cpu.gen_csr.csr.mcause3_0\[0\] _0502_ _0503_ VGND VGND VPWR VPWR _0504_ sky130_fd_sc_hd__mux2_1
XFILLER_0_6_135 VGND VGND VPWR VPWR sky130_fd_sc_hd__fill_1
XFILLER_0_12_71 VPWR VGND VPWR VGND sky130_ef_sc_hd__decap_12
XFILLER_0_27_274 VGND VGND VPWR VPWR sky130_fd_sc_hd__decap_6
Xoutput133 net133 VGND VGND VPWR VPWR o_dbus_sel[1] sky130_fd_sc_hd__clkbuf_4
Xoutput122 net122 VGND VGND VPWR VPWR o_dbus_dat[2] sky130_fd_sc_hd__clkbuf_4
Xoutput166 net166 VGND VGND VPWR VPWR o_ibus_adr[7] sky130_fd_sc_hd__clkbuf_4
Xoutput100 net100 VGND VGND VPWR VPWR o_dbus_dat[0] sky130_fd_sc_hd__clkbuf_4
Xoutput177 net177 VGND VGND VPWR VPWR o_raddr[7] sky130_fd_sc_hd__buf_2
Xoutput144 net144 VGND VGND VPWR VPWR o_ibus_adr[16] sky130_fd_sc_hd__clkbuf_4
Xoutput155 net155 VGND VGND VPWR VPWR o_ibus_adr[26] sky130_fd_sc_hd__clkbuf_4
Xoutput111 net111 VGND VGND VPWR VPWR o_dbus_dat[1] sky130_fd_sc_hd__buf_2
X_0887_ rf_ram_if.rdata1 net66 rf_ram_if.rtrig1 VGND VGND VPWR VPWR _0451_ sky130_fd_sc_hd__mux2_1
Xoutput188 net188 VGND VGND VPWR VPWR o_waddr[8] sky130_fd_sc_hd__clkbuf_4
X_1508_ clknet_4_5_0_clk _0170_ VGND VGND VPWR VPWR cpu.state.cnt_r\[1\] sky130_fd_sc_hd__dfxtp_1
X_1439_ clknet_4_2_0_clk _0102_ VGND VGND VPWR VPWR net123 sky130_fd_sc_hd__dfxtp_1
XFILLER_0_33_233 VPWR VGND VPWR VGND sky130_ef_sc_hd__decap_12
XFILLER_0_17_27 VGND VGND VPWR VPWR sky130_fd_sc_hd__decap_4
Xinput13 i_dbus_rdt[1] VGND VGND VPWR VPWR net13 sky130_fd_sc_hd__clkbuf_1
X_0810_ cpu.alu.i_rs1 cpu.csr_imm _0300_ VGND VGND VPWR VPWR _0391_ sky130_fd_sc_hd__mux2_1
X_0672_ _0266_ _0267_ VGND VGND VPWR VPWR _0268_ sky130_fd_sc_hd__or2_2
Xinput68 i_timer_irq VGND VGND VPWR VPWR net68 sky130_fd_sc_hd__buf_1
XFILLER_0_3_149 VGND VGND VPWR VPWR sky130_fd_sc_hd__fill_1
XFILLER_0_3_105 VGND VGND VPWR VPWR sky130_fd_sc_hd__decap_6
Xinput46 i_ibus_rdt[21] VGND VGND VPWR VPWR net46 sky130_fd_sc_hd__buf_1
Xinput24 i_dbus_rdt[2] VGND VGND VPWR VPWR net24 sky130_fd_sc_hd__buf_1
Xinput35 i_ibus_rdt[10] VGND VGND VPWR VPWR net35 sky130_fd_sc_hd__buf_1
Xinput57 i_ibus_rdt[31] VGND VGND VPWR VPWR net57 sky130_fd_sc_hd__clkbuf_1
X_0741_ cpu.branch_op _0265_ _0320_ _0321_ _0322_ VGND VGND VPWR VPWR _0323_ sky130_fd_sc_hd__o311a_1
X_1224_ _0289_ net55 _0420_ VGND VGND VPWR VPWR _0184_ sky130_fd_sc_hd__mux2_1
X_1155_ _0617_ cpu.immdec.gen_immdec_w_eq_1.imm19_12_20\[3\] _0610_ VGND VGND VPWR
+ VPWR _0618_ sky130_fd_sc_hd__mux2_1
X_1086_ _0563_ VGND VGND VPWR VPWR _0095_ sky130_fd_sc_hd__clkbuf_1
X_0939_ cpu.gen_csr.csr.mstatus_mie _0488_ _0490_ _0272_ VGND VGND VPWR VPWR _0021_
+ sky130_fd_sc_hd__a22o_1
XFILLER_0_15_255 VGND VGND VPWR VPWR sky130_fd_sc_hd__fill_2
XFILLER_0_15_277 VGND VGND VPWR VPWR sky130_fd_sc_hd__decap_3
XFILLER_0_23_81 VGND VGND VPWR VPWR sky130_fd_sc_hd__decap_4
XFILLER_0_2_193 VGND VGND VPWR VPWR sky130_fd_sc_hd__decap_3
Xclkbuf_4_5_0_clk clknet_0_clk VGND VGND VPWR VPWR clknet_4_5_0_clk sky130_fd_sc_hd__clkbuf_8
XFILLER_0_21_225 VPWR VGND VPWR VGND sky130_ef_sc_hd__decap_12
XFILLER_0_28_15 VGND VGND VPWR VPWR sky130_fd_sc_hd__fill_1
XFILLER_0_29_303 VGND VGND VPWR VPWR sky130_fd_sc_hd__decap_8
XFILLER_0_12_203 VGND VGND VPWR VPWR sky130_fd_sc_hd__fill_1
X_0724_ cpu.decode.co_mem_word cpu.bne_or_bge VGND VGND VPWR VPWR _0306_ sky130_fd_sc_hd__and2b_1
X_0655_ rf_ram_if.rtrig0 VGND VGND VPWR VPWR _0252_ sky130_fd_sc_hd__buf_4
XFILLER_0_40_6 VPWR VGND VPWR VGND sky130_ef_sc_hd__decap_12
X_1207_ cpu.immdec.gen_immdec_w_eq_1.imm24_20\[3\] _0651_ _0652_ cpu.immdec.gen_immdec_w_eq_1.imm24_20\[2\]
+ _0176_ VGND VGND VPWR VPWR _0125_ sky130_fd_sc_hd__a221o_1
XFILLER_0_19_3 VGND VGND VPWR VPWR sky130_fd_sc_hd__fill_2
XFILLER_0_47_144 VGND VGND VPWR VPWR sky130_fd_sc_hd__decap_4
X_1069_ _0554_ VGND VGND VPWR VPWR _0087_ sky130_fd_sc_hd__clkbuf_1
X_1138_ cpu.immdec.gen_immdec_w_eq_1.imm31 net57 _0420_ VGND VGND VPWR VPWR _0605_
+ sky130_fd_sc_hd__mux2_1
XFILLER_0_50_309 VGND VGND VPWR VPWR sky130_fd_sc_hd__fill_1
XFILLER_0_38_122 VGND VGND VPWR VPWR sky130_fd_sc_hd__decap_3
XTAP_206 VGND VPWR sky130_fd_sc_hd__tapvpwrvgnd_1
XTAP_217 VGND VPWR sky130_fd_sc_hd__tapvpwrvgnd_1
XTAP_228 VGND VPWR sky130_fd_sc_hd__tapvpwrvgnd_1
XTAP_239 VGND VPWR sky130_fd_sc_hd__tapvpwrvgnd_1
Xhold2 rf_ram_if.wdata1_r\[1\] VGND VGND VPWR VPWR net198 sky130_fd_sc_hd__dlygate4sd3_1
XFILLER_0_29_177 VGND VGND VPWR VPWR sky130_fd_sc_hd__decap_3
XFILLER_0_29_133 VPWR VGND VPWR VGND sky130_ef_sc_hd__decap_12
XFILLER_0_29_111 VGND VGND VPWR VPWR sky130_fd_sc_hd__fill_1
XFILLER_0_52_191 VGND VGND VPWR VPWR sky130_fd_sc_hd__decap_4
XFILLER_0_32_309 VGND VGND VPWR VPWR sky130_fd_sc_hd__fill_2
XFILLER_0_4_277 VPWR VGND VPWR VGND sky130_ef_sc_hd__decap_12
X_0707_ cpu.decode.opcode\[0\] VGND VGND VPWR VPWR _0289_ sky130_fd_sc_hd__clkbuf_4
XFILLER_0_29_80 VPWR VGND VPWR VGND sky130_ef_sc_hd__decap_12
XFILLER_0_45_90 VPWR VGND VPWR VGND sky130_ef_sc_hd__decap_12
XFILLER_0_35_147 VGND VGND VPWR VPWR sky130_fd_sc_hd__fill_1
XFILLER_0_50_139 VGND VGND VPWR VPWR sky130_fd_sc_hd__fill_1
XFILLER_0_1_225 VPWR VGND VPWR VGND sky130_ef_sc_hd__decap_12
XFILLER_0_14_309 VGND VGND VPWR VPWR sky130_fd_sc_hd__decap_4
X_1472_ clknet_4_9_0_clk _0134_ VGND VGND VPWR VPWR cpu.bufreg.i_right_shift_op sky130_fd_sc_hd__dfxtp_1
XFILLER_0_40_194 VGND VGND VPWR VPWR sky130_fd_sc_hd__fill_2
XFILLER_0_40_150 VGND VGND VPWR VPWR sky130_fd_sc_hd__decap_6
XFILLER_0_31_183 VGND VGND VPWR VPWR sky130_fd_sc_hd__fill_1
XFILLER_0_36_26 VGND VGND VPWR VPWR sky130_fd_sc_hd__fill_2
X_0972_ _0419_ VGND VGND VPWR VPWR _0515_ sky130_fd_sc_hd__buf_4
XFILLER_0_10_301 VGND VGND VPWR VPWR sky130_fd_sc_hd__decap_6
X_1386_ clknet_4_0_0_clk _0051_ VGND VGND VPWR VPWR net145 sky130_fd_sc_hd__dfxtp_1
X_1455_ clknet_4_9_0_clk _0117_ VGND VGND VPWR VPWR cpu.immdec.gen_immdec_w_eq_1.imm30_25\[0\]
+ sky130_fd_sc_hd__dfxtp_1
XFILLER_0_45_275 VGND VGND VPWR VPWR sky130_fd_sc_hd__decap_4
XPHY_95 VGND VGND VPWR VPWR sky130_fd_sc_hd__decap_3
XPHY_84 VGND VGND VPWR VPWR sky130_fd_sc_hd__decap_3
XPHY_73 VGND VGND VPWR VPWR sky130_fd_sc_hd__decap_3
XPHY_62 VGND VGND VPWR VPWR sky130_fd_sc_hd__decap_3
XPHY_40 VGND VGND VPWR VPWR sky130_fd_sc_hd__decap_3
XPHY_51 VGND VGND VPWR VPWR sky130_fd_sc_hd__decap_3
XFILLER_0_36_264 VGND VGND VPWR VPWR sky130_fd_sc_hd__decap_6
XFILLER_0_47_69 VPWR VGND VPWR VGND sky130_ef_sc_hd__decap_12
X_1171_ _0288_ cpu.immdec.gen_immdec_w_eq_1.imm24_20\[0\] _0447_ VGND VGND VPWR VPWR
+ _0629_ sky130_fd_sc_hd__o21a_1
XFILLER_0_2_16 VPWR VGND VPWR VGND sky130_ef_sc_hd__decap_12
X_1240_ _0193_ VGND VGND VPWR VPWR _0141_ sky130_fd_sc_hd__clkbuf_1
XFILLER_0_19_209 VGND VGND VPWR VPWR sky130_fd_sc_hd__decap_3
X_0955_ _0397_ _0337_ _0364_ _0486_ VGND VGND VPWR VPWR _0503_ sky130_fd_sc_hd__a31o_1
X_0886_ _0450_ VGND VGND VPWR VPWR _0008_ sky130_fd_sc_hd__clkbuf_1
XFILLER_0_12_50 VGND VGND VPWR VPWR sky130_fd_sc_hd__fill_2
XFILLER_0_12_83 VGND VGND VPWR VPWR sky130_fd_sc_hd__fill_1
Xoutput101 net101 VGND VGND VPWR VPWR o_dbus_dat[10] sky130_fd_sc_hd__clkbuf_4
Xoutput178 net178 VGND VGND VPWR VPWR o_raddr[8] sky130_fd_sc_hd__clkbuf_4
XFILLER_0_42_289 VGND VGND VPWR VPWR sky130_fd_sc_hd__fill_1
Xoutput167 net167 VGND VGND VPWR VPWR o_ibus_adr[8] sky130_fd_sc_hd__clkbuf_4
X_1507_ clknet_4_4_0_clk _0169_ VGND VGND VPWR VPWR cpu.state.cnt_r\[0\] sky130_fd_sc_hd__dfxtp_1
Xoutput189 net189 VGND VGND VPWR VPWR o_waddr[9] sky130_fd_sc_hd__clkbuf_4
Xoutput145 net145 VGND VGND VPWR VPWR o_ibus_adr[17] sky130_fd_sc_hd__clkbuf_4
Xoutput134 net134 VGND VGND VPWR VPWR o_dbus_sel[2] sky130_fd_sc_hd__clkbuf_4
Xoutput112 net112 VGND VGND VPWR VPWR o_dbus_dat[20] sky130_fd_sc_hd__clkbuf_4
Xoutput156 net156 VGND VGND VPWR VPWR o_ibus_adr[27] sky130_fd_sc_hd__buf_2
Xoutput123 net123 VGND VGND VPWR VPWR o_dbus_dat[30] sky130_fd_sc_hd__buf_2
X_1369_ clknet_4_4_0_clk _0034_ VGND VGND VPWR VPWR net137 sky130_fd_sc_hd__dfxtp_2
X_1438_ clknet_4_8_0_clk _0101_ VGND VGND VPWR VPWR net121 sky130_fd_sc_hd__dfxtp_1
XFILLER_0_10_197 VGND VGND VPWR VPWR sky130_fd_sc_hd__fill_2
XFILLER_0_33_245 VGND VGND VPWR VPWR sky130_fd_sc_hd__fill_1
XFILLER_0_33_223 VGND VGND VPWR VPWR sky130_fd_sc_hd__fill_1
XFILLER_0_33_201 VGND VGND VPWR VPWR sky130_fd_sc_hd__fill_1
Xinput14 i_dbus_rdt[20] VGND VGND VPWR VPWR net14 sky130_fd_sc_hd__buf_1
X_0740_ _0310_ cpu.state.cnt_r\[0\] cpu.state.cnt_r\[1\] cpu.state.cnt_r\[2\] VGND
+ VGND VPWR VPWR _0322_ sky130_fd_sc_hd__or4_2
Xinput36 i_ibus_rdt[11] VGND VGND VPWR VPWR net36 sky130_fd_sc_hd__clkbuf_1
Xinput25 i_dbus_rdt[30] VGND VGND VPWR VPWR net25 sky130_fd_sc_hd__clkbuf_1
X_0671_ cpu.decode.op21 _0258_ _0261_ VGND VGND VPWR VPWR _0267_ sky130_fd_sc_hd__and3_1
Xinput58 i_ibus_rdt[3] VGND VGND VPWR VPWR net58 sky130_fd_sc_hd__buf_1
Xinput47 i_ibus_rdt[22] VGND VGND VPWR VPWR net47 sky130_fd_sc_hd__buf_1
XFILLER_0_24_278 VPWR VGND VPWR VGND sky130_ef_sc_hd__decap_12
X_1154_ cpu.csr_imm net39 _0614_ VGND VGND VPWR VPWR _0617_ sky130_fd_sc_hd__mux2_1
X_1223_ _0183_ VGND VGND VPWR VPWR _0134_ sky130_fd_sc_hd__clkbuf_1
X_1085_ net91 _0562_ _0324_ VGND VGND VPWR VPWR _0563_ sky130_fd_sc_hd__mux2_1
X_0938_ _0267_ _0394_ _0487_ _0489_ VGND VGND VPWR VPWR _0490_ sky130_fd_sc_hd__o211a_1
XFILLER_0_30_237 VGND VGND VPWR VPWR sky130_fd_sc_hd__decap_3
XFILLER_0_15_223 VGND VGND VPWR VPWR sky130_fd_sc_hd__fill_1
XFILLER_0_15_289 VGND VGND VPWR VPWR sky130_fd_sc_hd__fill_2
X_0869_ _0435_ _0436_ VGND VGND VPWR VPWR _0437_ sky130_fd_sc_hd__nor2_1
XFILLER_0_3_81 VPWR VGND VPWR VGND sky130_ef_sc_hd__decap_12
XFILLER_0_21_215 VGND VGND VPWR VPWR sky130_fd_sc_hd__decap_8
XFILLER_0_21_237 VGND VGND VPWR VPWR sky130_fd_sc_hd__fill_1
XFILLER_0_28_27 VGND VGND VPWR VPWR sky130_fd_sc_hd__fill_1
XFILLER_0_8_209 VPWR VGND VPWR VGND sky130_ef_sc_hd__decap_12
X_0723_ cpu.bufreg.i_right_shift_op cpu.decode.co_mem_word VGND VGND VPWR VPWR _0305_
+ sky130_fd_sc_hd__and2b_1
X_0654_ cpu.bufreg.data\[1\] cpu.bufreg.data\[0\] VGND VGND VPWR VPWR net132 sky130_fd_sc_hd__nor2_1
X_1137_ _0448_ net201 _0483_ VGND VGND VPWR VPWR _0105_ sky130_fd_sc_hd__a21bo_1
X_1206_ _0419_ net47 VGND VGND VPWR VPWR _0176_ sky130_fd_sc_hd__and2_1
XFILLER_0_47_134 VGND VGND VPWR VPWR sky130_fd_sc_hd__fill_1
X_1068_ net82 net83 _0550_ VGND VGND VPWR VPWR _0554_ sky130_fd_sc_hd__mux2_1
XFILLER_0_11_281 VPWR VGND VPWR VGND sky130_ef_sc_hd__decap_12
XFILLER_0_38_101 VGND VGND VPWR VPWR sky130_fd_sc_hd__decap_3
XFILLER_0_14_29 VGND VGND VPWR VPWR sky130_fd_sc_hd__fill_2
XTAP_207 VGND VPWR sky130_fd_sc_hd__tapvpwrvgnd_1
XTAP_218 VGND VPWR sky130_fd_sc_hd__tapvpwrvgnd_1
XTAP_229 VGND VPWR sky130_fd_sc_hd__tapvpwrvgnd_1
Xhold3 rf_ram_if.wdata0_r\[1\] VGND VGND VPWR VPWR net199 sky130_fd_sc_hd__dlygate4sd3_1
XFILLER_0_44_137 VGND VGND VPWR VPWR sky130_fd_sc_hd__decap_3
XFILLER_0_29_189 VGND VGND VPWR VPWR sky130_fd_sc_hd__decap_6
XFILLER_0_29_145 VPWR VGND VPWR VGND sky130_ef_sc_hd__decap_12
XFILLER_0_52_181 VGND VGND VPWR VPWR sky130_fd_sc_hd__decap_4
Xclkbuf_4_4_0_clk clknet_0_clk VGND VGND VPWR VPWR clknet_4_4_0_clk sky130_fd_sc_hd__clkbuf_8
XFILLER_0_4_289 VPWR VGND VPWR VGND sky130_ef_sc_hd__decap_12
XFILLER_0_20_83 VGND VGND VPWR VPWR sky130_fd_sc_hd__fill_1
X_0706_ cpu.branch_op VGND VGND VPWR VPWR _0288_ sky130_fd_sc_hd__clkbuf_4
XFILLER_0_31_3 VGND VGND VPWR VPWR sky130_fd_sc_hd__decap_3
XFILLER_0_29_92 VGND VGND VPWR VPWR sky130_fd_sc_hd__fill_1
XFILLER_0_9_80 VGND VGND VPWR VPWR sky130_fd_sc_hd__decap_8
XFILLER_0_26_115 VGND VGND VPWR VPWR sky130_fd_sc_hd__fill_2
XFILLER_0_1_237 VPWR VGND VPWR VGND sky130_ef_sc_hd__decap_12
XFILLER_0_5_49 VGND VGND VPWR VPWR sky130_fd_sc_hd__decap_6
X_1471_ clknet_4_9_0_clk _0133_ VGND VGND VPWR VPWR cpu.decode.co_mem_word sky130_fd_sc_hd__dfxtp_1
XFILLER_0_0_281 VGND VGND VPWR VPWR sky130_fd_sc_hd__fill_2
XFILLER_0_48_262 VGND VGND VPWR VPWR sky130_fd_sc_hd__fill_1
XFILLER_0_52_37 VGND VGND VPWR VPWR sky130_fd_sc_hd__fill_1
XFILLER_0_39_251 VGND VGND VPWR VPWR sky130_fd_sc_hd__fill_1
X_0971_ _0457_ _0397_ _0447_ VGND VGND VPWR VPWR _0514_ sky130_fd_sc_hd__and3b_1
XFILLER_0_6_307 VGND VGND VPWR VPWR sky130_fd_sc_hd__fill_1
X_1454_ clknet_4_9_0_clk _0116_ VGND VGND VPWR VPWR cpu.immdec.gen_immdec_w_eq_1.imm7
+ sky130_fd_sc_hd__dfxtp_1
X_1385_ clknet_4_0_0_clk _0050_ VGND VGND VPWR VPWR net144 sky130_fd_sc_hd__dfxtp_1
XFILLER_0_9_167 VGND VGND VPWR VPWR sky130_fd_sc_hd__fill_1
XFILLER_0_45_265 VGND VGND VPWR VPWR sky130_fd_sc_hd__fill_1
XFILLER_0_45_243 VGND VGND VPWR VPWR sky130_fd_sc_hd__fill_2
XTAP_390 VGND VPWR sky130_fd_sc_hd__tapvpwrvgnd_1
XPHY_30 VGND VGND VPWR VPWR sky130_fd_sc_hd__decap_3
XPHY_96 VGND VGND VPWR VPWR sky130_fd_sc_hd__decap_3
XPHY_85 VGND VGND VPWR VPWR sky130_fd_sc_hd__decap_3
XPHY_74 VGND VGND VPWR VPWR sky130_fd_sc_hd__decap_3
XFILLER_0_36_210 VGND VGND VPWR VPWR sky130_fd_sc_hd__fill_1
XPHY_63 VGND VGND VPWR VPWR sky130_fd_sc_hd__decap_3
XPHY_41 VGND VGND VPWR VPWR sky130_fd_sc_hd__decap_3
XFILLER_0_22_29 VPWR VGND VPWR VGND sky130_ef_sc_hd__decap_12
XPHY_52 VGND VGND VPWR VPWR sky130_fd_sc_hd__decap_3
XFILLER_0_51_279 VGND VGND VPWR VPWR sky130_fd_sc_hd__fill_1
X_1170_ _0288_ _0627_ VGND VGND VPWR VPWR _0628_ sky130_fd_sc_hd__nand2_1
XFILLER_0_42_224 VGND VGND VPWR VPWR sky130_fd_sc_hd__decap_4
X_0954_ _0501_ cpu.gen_csr.csr.mcause3_0\[1\] _0264_ VGND VGND VPWR VPWR _0502_ sky130_fd_sc_hd__a21o_1
XFILLER_0_6_115 VPWR VGND VPWR VGND sky130_ef_sc_hd__decap_12
X_0885_ _0415_ rf_ram_if.rreq_r VGND VGND VPWR VPWR _0450_ sky130_fd_sc_hd__and2b_1
Xoutput124 net124 VGND VGND VPWR VPWR o_dbus_dat[31] sky130_fd_sc_hd__clkbuf_4
Xoutput168 net168 VGND VGND VPWR VPWR o_ibus_adr[9] sky130_fd_sc_hd__clkbuf_4
Xoutput102 net102 VGND VGND VPWR VPWR o_dbus_dat[11] sky130_fd_sc_hd__clkbuf_4
Xoutput179 net179 VGND VGND VPWR VPWR o_raddr[9] sky130_fd_sc_hd__buf_2
Xoutput113 net113 VGND VGND VPWR VPWR o_dbus_dat[21] sky130_fd_sc_hd__buf_2
Xoutput146 net146 VGND VGND VPWR VPWR o_ibus_adr[18] sky130_fd_sc_hd__buf_2
X_1437_ clknet_4_2_0_clk _0100_ VGND VGND VPWR VPWR net120 sky130_fd_sc_hd__dfxtp_1
Xoutput157 net157 VGND VGND VPWR VPWR o_ibus_adr[28] sky130_fd_sc_hd__clkbuf_4
Xoutput135 net135 VGND VGND VPWR VPWR o_dbus_sel[3] sky130_fd_sc_hd__clkbuf_4
X_1506_ clknet_4_3_0_clk _0168_ VGND VGND VPWR VPWR cpu.mem_if.signbit sky130_fd_sc_hd__dfxtp_1
X_1299_ _0233_ VGND VGND VPWR VPWR _0160_ sky130_fd_sc_hd__clkbuf_1
X_1368_ clknet_4_8_0_clk _0001_ VGND VGND VPWR VPWR cpu.alu.add_cy_r sky130_fd_sc_hd__dfxtp_1
Xinput37 i_ibus_rdt[12] VGND VGND VPWR VPWR net37 sky130_fd_sc_hd__buf_1
Xinput26 i_dbus_rdt[31] VGND VGND VPWR VPWR net26 sky130_fd_sc_hd__buf_1
Xinput48 i_ibus_rdt[23] VGND VGND VPWR VPWR net48 sky130_fd_sc_hd__buf_1
X_0670_ _0265_ VGND VGND VPWR VPWR _0266_ sky130_fd_sc_hd__buf_2
Xinput15 i_dbus_rdt[21] VGND VGND VPWR VPWR net15 sky130_fd_sc_hd__clkbuf_1
Xinput59 i_ibus_rdt[4] VGND VGND VPWR VPWR net59 sky130_fd_sc_hd__clkbuf_1
X_1153_ _0616_ VGND VGND VPWR VPWR _0109_ sky130_fd_sc_hd__clkbuf_1
X_1084_ cpu.bufreg.i_sh_signed net91 _0401_ _0478_ VGND VGND VPWR VPWR _0562_ sky130_fd_sc_hd__a31o_1
X_1222_ _0300_ net39 _0420_ VGND VGND VPWR VPWR _0183_ sky130_fd_sc_hd__mux2_1
XFILLER_0_47_305 VGND VGND VPWR VPWR sky130_fd_sc_hd__decap_4
XFILLER_0_15_202 VGND VGND VPWR VPWR sky130_fd_sc_hd__fill_1
X_0937_ cpu.gen_csr.csr.mstatus_mpie _0267_ VGND VGND VPWR VPWR _0489_ sky130_fd_sc_hd__or2b_1
X_0799_ _0380_ VGND VGND VPWR VPWR _0381_ sky130_fd_sc_hd__inv_2
X_0868_ _0401_ _0314_ VGND VGND VPWR VPWR _0436_ sky130_fd_sc_hd__or2_2
XFILLER_0_48_91 VGND VGND VPWR VPWR sky130_fd_sc_hd__fill_1
XFILLER_0_3_93 VPWR VGND VPWR VGND sky130_ef_sc_hd__decap_12
XFILLER_0_44_27 VGND VGND VPWR VPWR sky130_fd_sc_hd__fill_1
X_0653_ net171 VGND VGND VPWR VPWR net181 sky130_fd_sc_hd__inv_2
XFILLER_0_8_27 VGND VGND VPWR VPWR sky130_fd_sc_hd__fill_1
X_0722_ cpu.state.init_done cpu.gen_csr.csr.o_new_irq VGND VGND VPWR VPWR _0304_ sky130_fd_sc_hd__or2_1
X_1067_ _0553_ VGND VGND VPWR VPWR _0086_ sky130_fd_sc_hd__clkbuf_1
X_1205_ cpu.immdec.gen_immdec_w_eq_1.imm24_20\[2\] _0651_ _0652_ cpu.immdec.gen_immdec_w_eq_1.imm24_20\[1\]
+ _0175_ VGND VGND VPWR VPWR _0124_ sky130_fd_sc_hd__a221o_1
X_1136_ _0604_ VGND VGND VPWR VPWR _0104_ sky130_fd_sc_hd__clkbuf_1
XFILLER_0_47_179 VPWR VGND VPWR VGND sky130_ef_sc_hd__decap_12
XFILLER_0_7_221 VGND VGND VPWR VPWR sky130_fd_sc_hd__decap_3
XFILLER_0_11_293 VPWR VGND VPWR VGND sky130_ef_sc_hd__decap_12
XFILLER_0_14_19 VGND VGND VPWR VPWR sky130_fd_sc_hd__decap_8
XFILLER_0_30_29 VPWR VGND VPWR VGND sky130_ef_sc_hd__decap_12
XFILLER_0_39_38 VGND VGND VPWR VPWR sky130_fd_sc_hd__decap_8
XTAP_208 VGND VPWR sky130_fd_sc_hd__tapvpwrvgnd_1
XTAP_219 VGND VPWR sky130_fd_sc_hd__tapvpwrvgnd_1
Xhold4 rf_ram_if.rtrig0 VGND VGND VPWR VPWR net200 sky130_fd_sc_hd__dlygate4sd3_1
XFILLER_0_29_157 VGND VGND VPWR VPWR sky130_fd_sc_hd__decap_8
XFILLER_0_52_160 VGND VGND VPWR VPWR sky130_fd_sc_hd__fill_2
X_0705_ _0287_ VGND VGND VPWR VPWR net191 sky130_fd_sc_hd__clkbuf_1
X_1119_ _0302_ _0591_ _0565_ VGND VGND VPWR VPWR _0592_ sky130_fd_sc_hd__or3b_1
XFILLER_0_31_300 VGND VGND VPWR VPWR sky130_fd_sc_hd__decap_8
XFILLER_0_41_39 VGND VGND VPWR VPWR sky130_fd_sc_hd__fill_1
XFILLER_0_41_108 VGND VGND VPWR VPWR sky130_fd_sc_hd__fill_1
XFILLER_0_34_160 VGND VGND VPWR VPWR sky130_fd_sc_hd__decap_3
XFILLER_0_1_249 VPWR VGND VPWR VGND sky130_ef_sc_hd__decap_12
X_1470_ clknet_4_9_0_clk _0132_ VGND VGND VPWR VPWR cpu.bne_or_bge sky130_fd_sc_hd__dfxtp_2
XFILLER_0_49_208 VGND VGND VPWR VPWR sky130_fd_sc_hd__decap_6
XFILLER_0_9_305 VGND VGND VPWR VPWR sky130_fd_sc_hd__decap_6
XFILLER_0_31_94 VGND VGND VPWR VPWR sky130_fd_sc_hd__fill_1
XFILLER_0_40_163 VGND VGND VPWR VPWR sky130_fd_sc_hd__decap_4
Xclkbuf_4_3_0_clk clknet_0_clk VGND VGND VPWR VPWR clknet_4_3_0_clk sky130_fd_sc_hd__clkbuf_8
X_0970_ _0513_ VGND VGND VPWR VPWR _0029_ sky130_fd_sc_hd__clkbuf_1
XFILLER_0_22_141 VGND VGND VPWR VPWR sky130_fd_sc_hd__decap_8
X_1453_ clknet_4_11_0_clk _0115_ VGND VGND VPWR VPWR cpu.immdec.gen_immdec_w_eq_1.imm19_12_20\[8\]
+ sky130_fd_sc_hd__dfxtp_1
X_1384_ clknet_4_1_0_clk _0049_ VGND VGND VPWR VPWR net143 sky130_fd_sc_hd__dfxtp_1
XFILLER_0_26_83 VGND VGND VPWR VPWR sky130_fd_sc_hd__fill_1
XFILLER_0_45_222 VGND VGND VPWR VPWR sky130_fd_sc_hd__fill_2
XFILLER_0_9_113 VGND VGND VPWR VPWR sky130_fd_sc_hd__decap_6
XFILLER_0_13_130 VPWR VGND VPWR VGND sky130_ef_sc_hd__decap_12
XTAP_391 VGND VPWR sky130_fd_sc_hd__tapvpwrvgnd_1
XTAP_380 VGND VPWR sky130_fd_sc_hd__tapvpwrvgnd_1
XPHY_64 VGND VGND VPWR VPWR sky130_fd_sc_hd__decap_3
XPHY_53 VGND VGND VPWR VPWR sky130_fd_sc_hd__decap_3
XPHY_20 VGND VGND VPWR VPWR sky130_fd_sc_hd__decap_3
XPHY_31 VGND VGND VPWR VPWR sky130_fd_sc_hd__decap_3
XPHY_42 VGND VGND VPWR VPWR sky130_fd_sc_hd__decap_3
XFILLER_0_51_225 VPWR VGND VPWR VGND sky130_ef_sc_hd__decap_12
XPHY_97 VGND VGND VPWR VPWR sky130_fd_sc_hd__decap_3
XPHY_86 VGND VGND VPWR VPWR sky130_fd_sc_hd__decap_3
XPHY_75 VGND VGND VPWR VPWR sky130_fd_sc_hd__decap_3
XFILLER_0_2_29 VPWR VGND VPWR VGND sky130_ef_sc_hd__decap_12
Xoutput103 net103 VGND VGND VPWR VPWR o_dbus_dat[12] sky130_fd_sc_hd__clkbuf_4
Xoutput125 net125 VGND VGND VPWR VPWR o_dbus_dat[3] sky130_fd_sc_hd__clkbuf_4
XFILLER_0_42_269 VPWR VGND VPWR VGND sky130_ef_sc_hd__decap_12
XFILLER_0_42_236 VPWR VGND VPWR VGND sky130_ef_sc_hd__decap_12
X_0953_ cpu.state.gen_csr.misalign_trap_sync_r VGND VGND VPWR VPWR _0501_ sky130_fd_sc_hd__inv_2
XFILLER_0_6_127 VGND VGND VPWR VPWR sky130_fd_sc_hd__decap_8
Xoutput114 net114 VGND VGND VPWR VPWR o_dbus_dat[22] sky130_fd_sc_hd__clkbuf_4
XFILLER_0_2_300 VGND VGND VPWR VPWR sky130_fd_sc_hd__fill_2
XFILLER_0_12_85 VGND VGND VPWR VPWR sky130_fd_sc_hd__decap_4
X_0884_ _0444_ _0449_ _0415_ VGND VGND VPWR VPWR _0007_ sky130_fd_sc_hd__a21oi_1
XFILLER_0_27_288 VGND VGND VPWR VPWR sky130_fd_sc_hd__decap_3
Xoutput169 net169 VGND VGND VPWR VPWR o_ibus_cyc sky130_fd_sc_hd__clkbuf_4
Xoutput147 net147 VGND VGND VPWR VPWR o_ibus_adr[19] sky130_fd_sc_hd__clkbuf_4
X_1367_ clknet_4_15_0_clk _0033_ VGND VGND VPWR VPWR cpu.immdec.gen_immdec_w_eq_1.imm11_7\[4\]
+ sky130_fd_sc_hd__dfxtp_1
Xoutput158 net158 VGND VGND VPWR VPWR o_ibus_adr[29] sky130_fd_sc_hd__clkbuf_4
X_1505_ clknet_4_7_0_clk _0167_ VGND VGND VPWR VPWR cpu.state.gen_csr.misalign_trap_sync_r
+ sky130_fd_sc_hd__dfxtp_1
X_1436_ clknet_4_2_0_clk _0099_ VGND VGND VPWR VPWR net119 sky130_fd_sc_hd__dfxtp_2
Xoutput136 net136 VGND VGND VPWR VPWR o_dbus_we sky130_fd_sc_hd__clkbuf_4
XFILLER_0_10_155 VPWR VGND VPWR VGND sky130_ef_sc_hd__decap_12
X_1298_ _0232_ net14 _0590_ VGND VGND VPWR VPWR _0233_ sky130_fd_sc_hd__mux2_1
Xinput38 i_ibus_rdt[13] VGND VGND VPWR VPWR net38 sky130_fd_sc_hd__buf_1
Xinput27 i_dbus_rdt[3] VGND VGND VPWR VPWR net27 sky130_fd_sc_hd__buf_1
Xinput49 i_ibus_rdt[24] VGND VGND VPWR VPWR net49 sky130_fd_sc_hd__clkbuf_1
Xinput16 i_dbus_rdt[22] VGND VGND VPWR VPWR net16 sky130_fd_sc_hd__buf_1
XFILLER_0_24_214 VPWR VGND VPWR VGND sky130_ef_sc_hd__decap_12
X_1221_ _0182_ VGND VGND VPWR VPWR _0133_ sky130_fd_sc_hd__clkbuf_1
X_1083_ _0561_ VGND VGND VPWR VPWR _0094_ sky130_fd_sc_hd__clkbuf_1
X_1152_ _0615_ cpu.immdec.gen_immdec_w_eq_1.imm19_12_20\[2\] _0610_ VGND VGND VPWR
+ VPWR _0616_ sky130_fd_sc_hd__mux2_1
X_0936_ _0487_ VGND VGND VPWR VPWR _0488_ sky130_fd_sc_hd__inv_2
XFILLER_0_15_214 VGND VGND VPWR VPWR sky130_fd_sc_hd__fill_1
XFILLER_0_15_225 VPWR VGND VPWR VGND sky130_ef_sc_hd__decap_12
XFILLER_0_15_247 VGND VGND VPWR VPWR sky130_fd_sc_hd__decap_8
X_0798_ _0378_ _0379_ VGND VGND VPWR VPWR _0380_ sky130_fd_sc_hd__and2_1
X_0867_ _0290_ _0421_ _0434_ VGND VGND VPWR VPWR _0435_ sky130_fd_sc_hd__a21oi_1
X_1419_ clknet_4_15_0_clk _0082_ VGND VGND VPWR VPWR net77 sky130_fd_sc_hd__dfxtp_1
XFILLER_0_28_29 VGND VGND VPWR VPWR sky130_fd_sc_hd__decap_4
XFILLER_0_44_309 VGND VGND VPWR VPWR sky130_fd_sc_hd__fill_2
X_0721_ net121 _0302_ VGND VGND VPWR VPWR _0303_ sky130_fd_sc_hd__xor2_1
X_1204_ _0419_ net46 VGND VGND VPWR VPWR _0175_ sky130_fd_sc_hd__and2_1
X_1066_ net81 net82 _0550_ VGND VGND VPWR VPWR _0553_ sky130_fd_sc_hd__mux2_1
XFILLER_0_34_50 VGND VGND VPWR VPWR sky130_fd_sc_hd__decap_8
X_1135_ cpu.alu.cmp_r _0432_ _0397_ VGND VGND VPWR VPWR _0604_ sky130_fd_sc_hd__mux2_1
XFILLER_0_47_169 VGND VGND VPWR VPWR sky130_fd_sc_hd__fill_1
X_0919_ cpu.bufreg.data\[0\] cpu.bufreg.data\[1\] _0475_ VGND VGND VPWR VPWR _0476_
+ sky130_fd_sc_hd__mux2_1
XFILLER_0_26_309 VGND VGND VPWR VPWR sky130_fd_sc_hd__fill_1
Xhold5 cpu.gen_csr.csr.timer_irq_r VGND VGND VPWR VPWR net201 sky130_fd_sc_hd__dlygate4sd3_1
XTAP_209 VGND VPWR sky130_fd_sc_hd__tapvpwrvgnd_1
XFILLER_0_29_103 VGND VGND VPWR VPWR sky130_fd_sc_hd__fill_1
XFILLER_0_44_106 VGND VGND VPWR VPWR sky130_fd_sc_hd__decap_6
XFILLER_0_29_169 VGND VGND VPWR VPWR sky130_fd_sc_hd__decap_8
XFILLER_0_20_52 VGND VGND VPWR VPWR sky130_fd_sc_hd__decap_4
X_0704_ rf_ram_if.wdata0_r\[1\] rf_ram_if.wdata1_r\[1\] _0252_ VGND VGND VPWR VPWR
+ _0287_ sky130_fd_sc_hd__mux2_1
X_1118_ net120 _0301_ VGND VGND VPWR VPWR _0591_ sky130_fd_sc_hd__and2_1
X_1049_ net73 net74 _0539_ VGND VGND VPWR VPWR _0544_ sky130_fd_sc_hd__mux2_1
XFILLER_0_50_109 VPWR VGND VPWR VGND sky130_ef_sc_hd__decap_12
XFILLER_0_35_139 VGND VGND VPWR VPWR sky130_fd_sc_hd__decap_8
XFILLER_0_41_29 VGND VGND VPWR VPWR sky130_fd_sc_hd__fill_1
XFILLER_0_26_128 VPWR VGND VPWR VGND sky130_ef_sc_hd__decap_12
XFILLER_0_34_183 VGND VGND VPWR VPWR sky130_fd_sc_hd__fill_1
XFILLER_0_15_41 VGND VGND VPWR VPWR sky130_fd_sc_hd__decap_8
XFILLER_0_13_301 VGND VGND VPWR VPWR sky130_fd_sc_hd__fill_1
XFILLER_0_25_172 VGND VGND VPWR VPWR sky130_fd_sc_hd__decap_6
XFILLER_0_40_197 VGND VGND VPWR VPWR sky130_fd_sc_hd__decap_3
XFILLER_0_0_272 VGND VGND VPWR VPWR sky130_fd_sc_hd__decap_4
XFILLER_0_0_261 VGND VGND VPWR VPWR sky130_fd_sc_hd__fill_1
XFILLER_0_48_220 VGND VGND VPWR VPWR sky130_fd_sc_hd__fill_1
XFILLER_0_48_242 VGND VGND VPWR VPWR sky130_fd_sc_hd__decap_4
XFILLER_0_31_175 VGND VGND VPWR VPWR sky130_fd_sc_hd__decap_4
XFILLER_0_39_297 VGND VGND VPWR VPWR sky130_fd_sc_hd__fill_1
XFILLER_0_6_309 VGND VGND VPWR VPWR sky130_fd_sc_hd__fill_2
X_1452_ clknet_4_14_0_clk _0114_ VGND VGND VPWR VPWR cpu.immdec.gen_immdec_w_eq_1.imm19_12_20\[7\]
+ sky130_fd_sc_hd__dfxtp_1
X_1383_ clknet_4_0_0_clk _0048_ VGND VGND VPWR VPWR net142 sky130_fd_sc_hd__dfxtp_1
XFILLER_0_42_83 VGND VGND VPWR VPWR sky130_fd_sc_hd__fill_1
XFILLER_0_9_169 VGND VGND VPWR VPWR sky130_fd_sc_hd__fill_2
XFILLER_0_13_142 VGND VGND VPWR VPWR sky130_fd_sc_hd__decap_8
XFILLER_0_13_175 VPWR VGND VPWR VGND sky130_ef_sc_hd__decap_12
XTAP_392 VGND VPWR sky130_fd_sc_hd__tapvpwrvgnd_1
XTAP_381 VGND VPWR sky130_fd_sc_hd__tapvpwrvgnd_1
XTAP_370 VGND VPWR sky130_fd_sc_hd__tapvpwrvgnd_1
XPHY_98 VGND VGND VPWR VPWR sky130_fd_sc_hd__decap_3
XPHY_87 VGND VGND VPWR VPWR sky130_fd_sc_hd__decap_3
XPHY_76 VGND VGND VPWR VPWR sky130_fd_sc_hd__decap_3
XPHY_65 VGND VGND VPWR VPWR sky130_fd_sc_hd__decap_3
XPHY_10 VGND VGND VPWR VPWR sky130_fd_sc_hd__decap_3
XPHY_21 VGND VGND VPWR VPWR sky130_fd_sc_hd__decap_3
XPHY_32 VGND VGND VPWR VPWR sky130_fd_sc_hd__decap_3
XPHY_43 VGND VGND VPWR VPWR sky130_fd_sc_hd__decap_3
XPHY_54 VGND VGND VPWR VPWR sky130_fd_sc_hd__decap_3
XFILLER_0_51_237 VPWR VGND VPWR VGND sky130_ef_sc_hd__decap_12
XFILLER_0_36_234 VGND VGND VPWR VPWR sky130_fd_sc_hd__fill_1
X_0952_ cpu.gen_csr.csr.o_new_irq _0395_ _0499_ _0500_ VGND VGND VPWR VPWR _0024_
+ sky130_fd_sc_hd__o31a_1
XFILLER_0_12_42 VGND VGND VPWR VPWR sky130_fd_sc_hd__decap_8
XFILLER_0_27_223 VGND VGND VPWR VPWR sky130_fd_sc_hd__fill_1
Xoutput104 net104 VGND VGND VPWR VPWR o_dbus_dat[13] sky130_fd_sc_hd__clkbuf_4
Xoutput115 net115 VGND VGND VPWR VPWR o_dbus_dat[23] sky130_fd_sc_hd__clkbuf_4
Xoutput126 net126 VGND VGND VPWR VPWR o_dbus_dat[4] sky130_fd_sc_hd__clkbuf_4
Xoutput137 net137 VGND VGND VPWR VPWR o_ibus_adr[0] sky130_fd_sc_hd__clkbuf_4
Xoutput159 net159 VGND VGND VPWR VPWR o_ibus_adr[2] sky130_fd_sc_hd__clkbuf_4
XFILLER_0_42_248 VGND VGND VPWR VPWR sky130_fd_sc_hd__decap_4
X_1504_ clknet_4_6_0_clk _0166_ VGND VGND VPWR VPWR cpu.bufreg2.i_bytecnt\[1\] sky130_fd_sc_hd__dfxtp_1
XFILLER_0_2_312 VGND VGND VPWR VPWR sky130_fd_sc_hd__fill_2
Xoutput148 net148 VGND VGND VPWR VPWR o_ibus_adr[1] sky130_fd_sc_hd__clkbuf_4
X_0883_ _0435_ _0436_ _0445_ _0446_ _0448_ VGND VGND VPWR VPWR _0449_ sky130_fd_sc_hd__o2111ai_1
X_1366_ clknet_4_13_0_clk _0032_ VGND VGND VPWR VPWR cpu.immdec.gen_immdec_w_eq_1.imm11_7\[3\]
+ sky130_fd_sc_hd__dfxtp_1
X_1435_ clknet_4_2_0_clk _0098_ VGND VGND VPWR VPWR net118 sky130_fd_sc_hd__dfxtp_1
XFILLER_0_10_167 VGND VGND VPWR VPWR sky130_fd_sc_hd__decap_4
X_1297_ net112 net113 _0572_ VGND VGND VPWR VPWR _0232_ sky130_fd_sc_hd__mux2_1
Xclkbuf_4_2_0_clk clknet_0_clk VGND VGND VPWR VPWR clknet_4_2_0_clk sky130_fd_sc_hd__clkbuf_8
XFILLER_0_18_245 VGND VGND VPWR VPWR sky130_fd_sc_hd__fill_1
XFILLER_0_41_281 VPWR VGND VPWR VGND sky130_ef_sc_hd__decap_12
XFILLER_0_41_270 VGND VGND VPWR VPWR sky130_fd_sc_hd__decap_8
XFILLER_0_33_19 VPWR VGND VPWR VGND sky130_ef_sc_hd__decap_12
Xinput39 i_ibus_rdt[14] VGND VGND VPWR VPWR net39 sky130_fd_sc_hd__buf_1
XFILLER_0_32_292 VPWR VGND VPWR VGND sky130_ef_sc_hd__decap_12
Xinput28 i_dbus_rdt[4] VGND VGND VPWR VPWR net28 sky130_fd_sc_hd__buf_1
Xinput17 i_dbus_rdt[23] VGND VGND VPWR VPWR net17 sky130_fd_sc_hd__clkbuf_1
XFILLER_0_24_226 VGND VGND VPWR VPWR sky130_fd_sc_hd__fill_2
X_1151_ cpu.immdec.gen_immdec_w_eq_1.imm19_12_20\[3\] net38 _0614_ VGND VGND VPWR
+ VPWR _0615_ sky130_fd_sc_hd__mux2_1
X_1220_ _0298_ net38 _0420_ VGND VGND VPWR VPWR _0182_ sky130_fd_sc_hd__mux2_1
X_1082_ net90 net91 _0324_ VGND VGND VPWR VPWR _0561_ sky130_fd_sc_hd__mux2_1
X_0935_ _0310_ _0337_ _0359_ _0486_ _0267_ VGND VGND VPWR VPWR _0487_ sky130_fd_sc_hd__a311o_1
XFILLER_0_15_237 VGND VGND VPWR VPWR sky130_fd_sc_hd__fill_1
X_0866_ _0289_ _0433_ cpu.bufreg.data\[1\] cpu.branch_op VGND VGND VPWR VPWR _0434_
+ sky130_fd_sc_hd__o211a_1
XFILLER_0_23_85 VGND VGND VPWR VPWR sky130_fd_sc_hd__fill_1
XFILLER_0_30_229 VGND VGND VPWR VPWR sky130_fd_sc_hd__fill_2
XFILLER_0_2_197 VPWR VGND VPWR VGND sky130_ef_sc_hd__decap_12
X_0797_ cpu.alu.add_cy_r cpu.alu.i_rs1 VGND VGND VPWR VPWR _0379_ sky130_fd_sc_hd__nand2_1
XFILLER_0_23_281 VGND VGND VPWR VPWR sky130_fd_sc_hd__decap_4
X_1418_ clknet_4_15_0_clk _0081_ VGND VGND VPWR VPWR net76 sky130_fd_sc_hd__dfxtp_1
X_1349_ clknet_4_8_0_clk _0015_ VGND VGND VPWR VPWR net173 sky130_fd_sc_hd__dfxtp_2
X_0720_ net120 _0301_ VGND VGND VPWR VPWR _0302_ sky130_fd_sc_hd__nor2_1
XFILLER_0_8_29 VPWR VGND VPWR VGND sky130_ef_sc_hd__decap_12
XFILLER_0_20_240 VGND VGND VPWR VPWR sky130_fd_sc_hd__decap_4
X_1203_ cpu.immdec.gen_immdec_w_eq_1.imm24_20\[1\] _0651_ _0652_ cpu.immdec.gen_immdec_w_eq_1.imm24_20\[0\]
+ _0606_ VGND VGND VPWR VPWR _0123_ sky130_fd_sc_hd__a221o_1
XFILLER_0_33_9 VGND VGND VPWR VPWR sky130_fd_sc_hd__fill_2
X_1134_ _0603_ VGND VGND VPWR VPWR _0103_ sky130_fd_sc_hd__clkbuf_1
X_1065_ _0552_ VGND VGND VPWR VPWR _0085_ sky130_fd_sc_hd__clkbuf_1
XFILLER_0_34_95 VGND VGND VPWR VPWR sky130_fd_sc_hd__decap_3
XFILLER_0_50_83 VGND VGND VPWR VPWR sky130_fd_sc_hd__fill_1
X_0849_ _0417_ _0418_ VGND VGND VPWR VPWR net182 sky130_fd_sc_hd__nand2_1
X_0918_ _0401_ _0324_ _0474_ VGND VGND VPWR VPWR _0475_ sky130_fd_sc_hd__a21o_1
Xhold6 cpu.immdec.gen_immdec_w_eq_1.imm30_25\[5\] VGND VGND VPWR VPWR net202 sky130_fd_sc_hd__dlygate4sd3_1
XFILLER_0_52_195 VGND VGND VPWR VPWR sky130_fd_sc_hd__fill_1
X_0703_ _0286_ VGND VGND VPWR VPWR net190 sky130_fd_sc_hd__clkbuf_1
X_1117_ _0567_ VGND VGND VPWR VPWR _0590_ sky130_fd_sc_hd__buf_4
X_1048_ _0543_ VGND VGND VPWR VPWR _0077_ sky130_fd_sc_hd__clkbuf_1
XFILLER_0_3_281 VPWR VGND VPWR VGND sky130_ef_sc_hd__decap_12
XFILLER_0_26_107 VGND VGND VPWR VPWR sky130_fd_sc_hd__decap_8
XFILLER_0_31_30 VGND VGND VPWR VPWR sky130_fd_sc_hd__decap_3
XFILLER_0_17_129 VPWR VGND VPWR VGND sky130_ef_sc_hd__decap_12
XFILLER_0_31_63 VGND VGND VPWR VPWR sky130_fd_sc_hd__decap_4
XFILLER_0_0_251 VGND VGND VPWR VPWR sky130_fd_sc_hd__fill_1
XFILLER_0_0_240 VGND VGND VPWR VPWR sky130_fd_sc_hd__fill_1
XFILLER_0_31_143 VPWR VGND VPWR VGND sky130_ef_sc_hd__decap_12
XFILLER_0_16_195 VGND VGND VPWR VPWR sky130_fd_sc_hd__fill_1
XFILLER_0_52_29 VGND VGND VPWR VPWR sky130_fd_sc_hd__fill_2
X_1451_ clknet_4_15_0_clk _0113_ VGND VGND VPWR VPWR cpu.immdec.gen_immdec_w_eq_1.imm19_12_20\[6\]
+ sky130_fd_sc_hd__dfxtp_1
X_1382_ clknet_4_1_0_clk _0047_ VGND VGND VPWR VPWR net141 sky130_fd_sc_hd__dfxtp_2
XFILLER_0_26_41 VPWR VGND VPWR VGND sky130_ef_sc_hd__decap_12
XFILLER_0_45_279 VGND VGND VPWR VPWR sky130_fd_sc_hd__fill_1
XFILLER_0_45_202 VGND VGND VPWR VPWR sky130_fd_sc_hd__fill_1
XFILLER_0_9_137 VGND VGND VPWR VPWR sky130_fd_sc_hd__decap_3
XFILLER_0_9_148 VGND VGND VPWR VPWR sky130_fd_sc_hd__decap_4
XFILLER_0_13_187 VGND VGND VPWR VPWR sky130_fd_sc_hd__fill_2
XTAP_393 VGND VPWR sky130_fd_sc_hd__tapvpwrvgnd_1
XTAP_382 VGND VPWR sky130_fd_sc_hd__tapvpwrvgnd_1
XTAP_371 VGND VPWR sky130_fd_sc_hd__tapvpwrvgnd_1
XTAP_360 VGND VPWR sky130_fd_sc_hd__tapvpwrvgnd_1
XPHY_99 VGND VGND VPWR VPWR sky130_fd_sc_hd__decap_3
XPHY_88 VGND VGND VPWR VPWR sky130_fd_sc_hd__decap_3
XPHY_77 VGND VGND VPWR VPWR sky130_fd_sc_hd__decap_3
XPHY_66 VGND VGND VPWR VPWR sky130_fd_sc_hd__decap_3
XPHY_55 VGND VGND VPWR VPWR sky130_fd_sc_hd__decap_3
XPHY_11 VGND VGND VPWR VPWR sky130_fd_sc_hd__decap_3
XPHY_22 VGND VGND VPWR VPWR sky130_fd_sc_hd__decap_3
XPHY_33 VGND VGND VPWR VPWR sky130_fd_sc_hd__decap_3
XPHY_44 VGND VGND VPWR VPWR sky130_fd_sc_hd__decap_3
XFILLER_0_51_249 VPWR VGND VPWR VGND sky130_ef_sc_hd__decap_12
X_0951_ cpu.gen_csr.csr.mcause31 _0499_ VGND VGND VPWR VPWR _0500_ sky130_fd_sc_hd__or2b_1
X_0882_ _0447_ VGND VGND VPWR VPWR _0448_ sky130_fd_sc_hd__clkbuf_4
Xoutput116 net116 VGND VGND VPWR VPWR o_dbus_dat[24] sky130_fd_sc_hd__clkbuf_4
X_1503_ clknet_4_7_0_clk _0165_ VGND VGND VPWR VPWR cpu.bufreg2.i_bytecnt\[0\] sky130_fd_sc_hd__dfxtp_1
XFILLER_0_35_290 VPWR VGND VPWR VGND sky130_ef_sc_hd__decap_12
Xoutput127 net127 VGND VGND VPWR VPWR o_dbus_dat[5] sky130_fd_sc_hd__clkbuf_4
Xoutput105 net105 VGND VGND VPWR VPWR o_dbus_dat[14] sky130_fd_sc_hd__clkbuf_4
Xoutput138 net138 VGND VGND VPWR VPWR o_ibus_adr[10] sky130_fd_sc_hd__clkbuf_4
Xoutput149 net149 VGND VGND VPWR VPWR o_ibus_adr[20] sky130_fd_sc_hd__clkbuf_4
X_1365_ clknet_4_13_0_clk _0031_ VGND VGND VPWR VPWR cpu.immdec.gen_immdec_w_eq_1.imm11_7\[2\]
+ sky130_fd_sc_hd__dfxtp_1
X_1296_ _0231_ VGND VGND VPWR VPWR _0159_ sky130_fd_sc_hd__clkbuf_1
XFILLER_0_37_84 VPWR VGND VPWR VGND sky130_ef_sc_hd__decap_12
XFILLER_0_37_73 VGND VGND VPWR VPWR sky130_fd_sc_hd__fill_1
X_1434_ clknet_4_3_0_clk _0097_ VGND VGND VPWR VPWR net117 sky130_fd_sc_hd__dfxtp_2
XFILLER_0_41_293 VGND VGND VPWR VPWR sky130_fd_sc_hd__decap_4
XTAP_190 VGND VPWR sky130_fd_sc_hd__tapvpwrvgnd_1
Xinput18 i_dbus_rdt[24] VGND VGND VPWR VPWR net18 sky130_fd_sc_hd__clkbuf_1
XFILLER_0_24_205 VGND VGND VPWR VPWR sky130_fd_sc_hd__fill_2
XFILLER_0_32_282 VGND VGND VPWR VPWR sky130_fd_sc_hd__fill_1
Xinput29 i_dbus_rdt[5] VGND VGND VPWR VPWR net29 sky130_fd_sc_hd__clkbuf_1
XFILLER_0_24_238 VGND VGND VPWR VPWR sky130_fd_sc_hd__decap_4
X_1150_ net34 VGND VGND VPWR VPWR _0614_ sky130_fd_sc_hd__buf_4
X_1081_ _0560_ VGND VGND VPWR VPWR _0093_ sky130_fd_sc_hd__clkbuf_1
X_0934_ _0272_ _0314_ VGND VGND VPWR VPWR _0486_ sky130_fd_sc_hd__nor2_1
X_0865_ _0345_ _0432_ VGND VGND VPWR VPWR _0433_ sky130_fd_sc_hd__xnor2_1
XFILLER_0_48_83 VGND VGND VPWR VPWR sky130_fd_sc_hd__fill_1
X_1417_ clknet_4_11_0_clk _0080_ VGND VGND VPWR VPWR net75 sky130_fd_sc_hd__dfxtp_1
X_0796_ cpu.alu.add_cy_r cpu.alu.i_rs1 VGND VGND VPWR VPWR _0378_ sky130_fd_sc_hd__or2_1
X_1279_ net105 net106 _0211_ VGND VGND VPWR VPWR _0220_ sky130_fd_sc_hd__mux2_1
XFILLER_0_3_30 VPWR VGND VPWR VGND sky130_ef_sc_hd__decap_12
X_1348_ clknet_4_0_0_clk _0014_ VGND VGND VPWR VPWR net172 sky130_fd_sc_hd__dfxtp_1
XFILLER_0_8_19 VGND VGND VPWR VPWR sky130_fd_sc_hd__decap_8
X_1064_ net80 net81 _0550_ VGND VGND VPWR VPWR _0552_ sky130_fd_sc_hd__mux2_1
X_1202_ _0515_ _0650_ VGND VGND VPWR VPWR _0652_ sky130_fd_sc_hd__nor2_1
X_1133_ net124 _0602_ _0574_ VGND VGND VPWR VPWR _0603_ sky130_fd_sc_hd__mux2_1
Xclkbuf_4_1_0_clk clknet_0_clk VGND VGND VPWR VPWR clknet_4_1_0_clk sky130_fd_sc_hd__clkbuf_8
X_0779_ _0312_ _0332_ cpu.state.cnt_r\[0\] _0360_ _0310_ VGND VGND VPWR VPWR _0361_
+ sky130_fd_sc_hd__a32o_1
X_0848_ net171 net172 VGND VGND VPWR VPWR _0418_ sky130_fd_sc_hd__nand2_1
XFILLER_0_7_279 VGND VGND VPWR VPWR sky130_fd_sc_hd__fill_1
X_0917_ _0401_ _0473_ VGND VGND VPWR VPWR _0474_ sky130_fd_sc_hd__nor2_1
Xhold7 cpu.state.ibus_cyc VGND VGND VPWR VPWR net203 sky130_fd_sc_hd__dlygate4sd3_1
XFILLER_0_52_141 VGND VGND VPWR VPWR sky130_fd_sc_hd__fill_2
X_0702_ rf_ram_if.wdata0_r\[0\] rf_ram_if.wdata1_r\[0\] _0252_ VGND VGND VPWR VPWR
+ _0286_ sky130_fd_sc_hd__mux2_1
XFILLER_0_29_63 VGND VGND VPWR VPWR sky130_fd_sc_hd__fill_1
XFILLER_0_29_41 VPWR VGND VPWR VGND sky130_ef_sc_hd__decap_12
XFILLER_0_45_73 VGND VGND VPWR VPWR sky130_fd_sc_hd__fill_1
X_1116_ _0586_ _0589_ _0574_ net119 VGND VGND VPWR VPWR _0099_ sky130_fd_sc_hd__o2bb2a_1
XFILLER_0_0_42 VGND VGND VPWR VPWR sky130_fd_sc_hd__fill_1
X_1047_ net72 net73 _0539_ VGND VGND VPWR VPWR _0543_ sky130_fd_sc_hd__mux2_1
XFILLER_0_24_6 VGND VGND VPWR VPWR sky130_fd_sc_hd__decap_6
XFILLER_0_0_97 VGND VGND VPWR VPWR sky130_fd_sc_hd__decap_4
XFILLER_0_43_196 VGND VGND VPWR VPWR sky130_fd_sc_hd__decap_4
XFILLER_0_3_293 VGND VGND VPWR VPWR sky130_fd_sc_hd__decap_8
XFILLER_0_34_141 VGND VGND VPWR VPWR sky130_fd_sc_hd__fill_1
XFILLER_0_1_208 VPWR VGND VPWR VGND sky130_ef_sc_hd__decap_12
XFILLER_0_19_193 VPWR VGND VPWR VGND sky130_ef_sc_hd__decap_12
XFILLER_0_15_65 VGND VGND VPWR VPWR sky130_fd_sc_hd__decap_3
XFILLER_0_15_87 VGND VGND VPWR VPWR sky130_fd_sc_hd__decap_3
XFILLER_0_0_296 VGND VGND VPWR VPWR sky130_fd_sc_hd__fill_1
XFILLER_0_48_288 VPWR VGND VPWR VGND sky130_ef_sc_hd__decap_12
XFILLER_0_16_141 VGND VGND VPWR VPWR sky130_fd_sc_hd__decap_6
XFILLER_0_31_155 VPWR VGND VPWR VGND sky130_ef_sc_hd__decap_12
X_1450_ clknet_4_15_0_clk _0112_ VGND VGND VPWR VPWR cpu.immdec.gen_immdec_w_eq_1.imm19_12_20\[5\]
+ sky130_fd_sc_hd__dfxtp_1
XFILLER_0_22_133 VGND VGND VPWR VPWR sky130_fd_sc_hd__decap_6
XFILLER_0_22_177 VGND VGND VPWR VPWR sky130_fd_sc_hd__fill_2
XFILLER_0_22_188 VGND VGND VPWR VPWR sky130_fd_sc_hd__decap_8
X_1381_ clknet_4_1_0_clk _0046_ VGND VGND VPWR VPWR net140 sky130_fd_sc_hd__dfxtp_1
XFILLER_0_26_53 VGND VGND VPWR VPWR sky130_fd_sc_hd__decap_6
XFILLER_0_45_225 VGND VGND VPWR VPWR sky130_fd_sc_hd__fill_2
XTAP_350 VGND VPWR sky130_fd_sc_hd__tapvpwrvgnd_1
XFILLER_0_6_85 VGND VGND VPWR VPWR sky130_fd_sc_hd__decap_4
XFILLER_0_13_166 VGND VGND VPWR VPWR sky130_fd_sc_hd__fill_2
XTAP_394 VGND VPWR sky130_fd_sc_hd__tapvpwrvgnd_1
XTAP_383 VGND VPWR sky130_fd_sc_hd__tapvpwrvgnd_1
XTAP_372 VGND VPWR sky130_fd_sc_hd__tapvpwrvgnd_1
XTAP_361 VGND VPWR sky130_fd_sc_hd__tapvpwrvgnd_1
XPHY_12 VGND VGND VPWR VPWR sky130_fd_sc_hd__decap_3
XPHY_89 VGND VGND VPWR VPWR sky130_fd_sc_hd__decap_3
XPHY_78 VGND VGND VPWR VPWR sky130_fd_sc_hd__decap_3
XPHY_67 VGND VGND VPWR VPWR sky130_fd_sc_hd__decap_3
XPHY_56 VGND VGND VPWR VPWR sky130_fd_sc_hd__decap_3
XPHY_23 VGND VGND VPWR VPWR sky130_fd_sc_hd__decap_3
XPHY_34 VGND VGND VPWR VPWR sky130_fd_sc_hd__decap_3
XPHY_45 VGND VGND VPWR VPWR sky130_fd_sc_hd__decap_3
X_0950_ _0329_ _0364_ _0266_ VGND VGND VPWR VPWR _0499_ sky130_fd_sc_hd__a21oi_1
X_0881_ net34 VGND VGND VPWR VPWR _0447_ sky130_fd_sc_hd__inv_2
XFILLER_0_6_108 VGND VGND VPWR VPWR sky130_fd_sc_hd__fill_1
Xoutput139 net139 VGND VGND VPWR VPWR o_ibus_adr[11] sky130_fd_sc_hd__clkbuf_4
Xoutput106 net106 VGND VGND VPWR VPWR o_dbus_dat[15] sky130_fd_sc_hd__clkbuf_4
X_1502_ clknet_4_6_0_clk _0164_ VGND VGND VPWR VPWR cpu.state.o_cnt\[2\] sky130_fd_sc_hd__dfxtp_1
Xoutput117 net117 VGND VGND VPWR VPWR o_dbus_dat[25] sky130_fd_sc_hd__clkbuf_4
X_1433_ clknet_4_2_0_clk _0096_ VGND VGND VPWR VPWR net116 sky130_fd_sc_hd__dfxtp_4
Xoutput128 net128 VGND VGND VPWR VPWR o_dbus_dat[6] sky130_fd_sc_hd__clkbuf_4
X_1364_ clknet_4_15_0_clk _0030_ VGND VGND VPWR VPWR cpu.immdec.gen_immdec_w_eq_1.imm11_7\[1\]
+ sky130_fd_sc_hd__dfxtp_1
X_1295_ _0230_ net12 _0590_ VGND VGND VPWR VPWR _0231_ sky130_fd_sc_hd__mux2_1
XFILLER_0_18_269 VPWR VGND VPWR VGND sky130_ef_sc_hd__decap_12
XTAP_180 VGND VPWR sky130_fd_sc_hd__tapvpwrvgnd_1
XTAP_191 VGND VPWR sky130_fd_sc_hd__tapvpwrvgnd_1
Xinput19 i_dbus_rdt[25] VGND VGND VPWR VPWR net19 sky130_fd_sc_hd__buf_1
X_1080_ net88 net90 _0550_ VGND VGND VPWR VPWR _0560_ sky130_fd_sc_hd__mux2_1
XFILLER_0_47_309 VGND VGND VPWR VPWR sky130_fd_sc_hd__fill_1
XFILLER_0_30_209 VGND VGND VPWR VPWR sky130_fd_sc_hd__decap_4
XFILLER_0_15_206 VGND VGND VPWR VPWR sky130_fd_sc_hd__decap_8
X_0864_ _0386_ _0422_ _0430_ _0431_ VGND VGND VPWR VPWR _0432_ sky130_fd_sc_hd__a2bb2o_1
X_0933_ _0485_ VGND VGND VPWR VPWR _0020_ sky130_fd_sc_hd__clkbuf_1
X_0795_ cpu.alu.cmp_r _0305_ _0338_ _0376_ VGND VGND VPWR VPWR _0377_ sky130_fd_sc_hd__a31o_1
X_1347_ clknet_4_0_0_clk _0013_ VGND VGND VPWR VPWR net171 sky130_fd_sc_hd__dfxtp_1
X_1416_ clknet_4_0_0_clk _0079_ VGND VGND VPWR VPWR net74 sky130_fd_sc_hd__dfxtp_1
X_1278_ _0219_ VGND VGND VPWR VPWR _0153_ sky130_fd_sc_hd__clkbuf_1
XFILLER_0_3_42 VPWR VGND VPWR VGND sky130_ef_sc_hd__decap_12
X_1201_ _0447_ _0650_ VGND VGND VPWR VPWR _0651_ sky130_fd_sc_hd__and2_1
XFILLER_0_18_21 VGND VGND VPWR VPWR sky130_fd_sc_hd__decap_6
XFILLER_0_20_253 VGND VGND VPWR VPWR sky130_fd_sc_hd__decap_4
X_1063_ _0551_ VGND VGND VPWR VPWR _0084_ sky130_fd_sc_hd__clkbuf_1
X_1132_ _0373_ net26 _0567_ VGND VGND VPWR VPWR _0602_ sky130_fd_sc_hd__mux2_1
XFILLER_0_50_85 VGND VGND VPWR VPWR sky130_fd_sc_hd__decap_8
XFILLER_0_50_41 VPWR VGND VPWR VGND sky130_ef_sc_hd__decap_12
X_0916_ cpu.state.cnt_r\[0\] cpu.state.cnt_r\[1\] _0337_ VGND VGND VPWR VPWR _0473_
+ sky130_fd_sc_hd__o21ai_1
XFILLER_0_7_225 VPWR VGND VPWR VGND sky130_ef_sc_hd__decap_12
X_0778_ _0332_ cpu.gen_csr.csr.mstatus_mie _0312_ VGND VGND VPWR VPWR _0360_ sky130_fd_sc_hd__o21ba_1
X_0847_ net171 net172 VGND VGND VPWR VPWR _0417_ sky130_fd_sc_hd__or2_2
XFILLER_0_38_139 VGND VGND VPWR VPWR sky130_fd_sc_hd__fill_1
Xhold8 net156 VGND VGND VPWR VPWR net204 sky130_fd_sc_hd__dlygate4sd3_1
XFILLER_0_37_161 VGND VGND VPWR VPWR sky130_fd_sc_hd__decap_6
X_0701_ _0285_ VGND VGND VPWR VPWR net188 sky130_fd_sc_hd__clkbuf_1
XFILLER_0_40_304 VGND VGND VPWR VPWR sky130_fd_sc_hd__fill_1
XFILLER_0_4_228 VPWR VGND VPWR VGND sky130_ef_sc_hd__decap_12
XFILLER_0_4_217 VGND VGND VPWR VPWR sky130_fd_sc_hd__fill_2
XFILLER_0_20_22 VGND VGND VPWR VPWR sky130_fd_sc_hd__decap_6
XFILLER_0_29_53 VGND VGND VPWR VPWR sky130_fd_sc_hd__decap_3
X_1046_ _0542_ VGND VGND VPWR VPWR _0076_ sky130_fd_sc_hd__clkbuf_1
XFILLER_0_0_65 VGND VGND VPWR VPWR sky130_fd_sc_hd__fill_1
X_1115_ _0565_ _0301_ _0587_ _0588_ _0579_ VGND VGND VPWR VPWR _0589_ sky130_fd_sc_hd__a311o_1
XFILLER_0_43_153 VPWR VGND VPWR VGND sky130_ef_sc_hd__decap_12
XFILLER_0_43_120 VGND VGND VPWR VPWR sky130_fd_sc_hd__decap_3
XFILLER_0_28_183 VGND VGND VPWR VPWR sky130_fd_sc_hd__fill_1
XFILLER_0_16_312 VGND VGND VPWR VPWR sky130_fd_sc_hd__fill_2
XFILLER_0_3_261 VPWR VGND VPWR VGND sky130_ef_sc_hd__decap_12
XFILLER_0_34_197 VGND VGND VPWR VPWR sky130_fd_sc_hd__decap_8
Xclkbuf_4_0_0_clk clknet_0_clk VGND VGND VPWR VPWR clknet_4_0_0_clk sky130_fd_sc_hd__clkbuf_8
XFILLER_0_40_101 VGND VGND VPWR VPWR sky130_fd_sc_hd__decap_4
XFILLER_0_25_164 VGND VGND VPWR VPWR sky130_fd_sc_hd__decap_4
XFILLER_0_40_167 VGND VGND VPWR VPWR sky130_fd_sc_hd__fill_1
XFILLER_0_40_156 VGND VGND VPWR VPWR sky130_fd_sc_hd__fill_1
XFILLER_0_40_134 VGND VGND VPWR VPWR sky130_fd_sc_hd__decap_3
XFILLER_0_0_253 VGND VGND VPWR VPWR sky130_fd_sc_hd__fill_2
X_1029_ _0533_ VGND VGND VPWR VPWR _0068_ sky130_fd_sc_hd__clkbuf_1
XFILLER_0_31_167 VGND VGND VPWR VPWR sky130_fd_sc_hd__fill_1
XFILLER_0_16_164 VGND VGND VPWR VPWR sky130_fd_sc_hd__decap_4
XFILLER_0_39_223 VGND VGND VPWR VPWR sky130_fd_sc_hd__fill_1
XFILLER_0_22_101 VGND VGND VPWR VPWR sky130_fd_sc_hd__fill_1
XFILLER_0_10_307 VGND VGND VPWR VPWR sky130_fd_sc_hd__fill_1
X_1380_ clknet_4_1_0_clk _0045_ VGND VGND VPWR VPWR net139 sky130_fd_sc_hd__dfxtp_1
XTAP_384 VGND VPWR sky130_fd_sc_hd__tapvpwrvgnd_1
XTAP_373 VGND VPWR sky130_fd_sc_hd__tapvpwrvgnd_1
XTAP_362 VGND VPWR sky130_fd_sc_hd__tapvpwrvgnd_1
XTAP_351 VGND VPWR sky130_fd_sc_hd__tapvpwrvgnd_1
XTAP_340 VGND VPWR sky130_fd_sc_hd__tapvpwrvgnd_1
XFILLER_0_6_42 VGND VGND VPWR VPWR sky130_fd_sc_hd__fill_1
XTAP_395 VGND VPWR sky130_fd_sc_hd__tapvpwrvgnd_1
XPHY_13 VGND VGND VPWR VPWR sky130_fd_sc_hd__decap_3
XPHY_24 VGND VGND VPWR VPWR sky130_fd_sc_hd__decap_3
XPHY_35 VGND VGND VPWR VPWR sky130_fd_sc_hd__decap_3
XPHY_46 VGND VGND VPWR VPWR sky130_fd_sc_hd__decap_3
XPHY_79 VGND VGND VPWR VPWR sky130_fd_sc_hd__decap_3
XPHY_68 VGND VGND VPWR VPWR sky130_fd_sc_hd__decap_3
XPHY_57 VGND VGND VPWR VPWR sky130_fd_sc_hd__decap_3
XFILLER_0_4_3 VGND VGND VPWR VPWR sky130_fd_sc_hd__fill_2
XFILLER_0_27_215 VGND VGND VPWR VPWR sky130_fd_sc_hd__fill_2
XFILLER_0_50_251 VGND VGND VPWR VPWR sky130_fd_sc_hd__fill_1
Xoutput107 net107 VGND VGND VPWR VPWR o_dbus_dat[16] sky130_fd_sc_hd__clkbuf_4
X_0880_ rf_ram_if.rtrig0 net170 VGND VGND VPWR VPWR _0446_ sky130_fd_sc_hd__or2_1
XFILLER_0_27_259 VGND VGND VPWR VPWR sky130_fd_sc_hd__decap_6
X_1363_ clknet_4_12_0_clk _0029_ VGND VGND VPWR VPWR cpu.immdec.gen_immdec_w_eq_1.imm11_7\[0\]
+ sky130_fd_sc_hd__dfxtp_1
Xoutput118 net118 VGND VGND VPWR VPWR o_dbus_dat[26] sky130_fd_sc_hd__clkbuf_4
X_1501_ clknet_4_8_0_clk _0163_ VGND VGND VPWR VPWR net115 sky130_fd_sc_hd__dfxtp_1
XFILLER_0_10_126 VPWR VGND VPWR VGND sky130_ef_sc_hd__decap_12
Xoutput129 net129 VGND VGND VPWR VPWR o_dbus_dat[7] sky130_fd_sc_hd__clkbuf_4
X_1432_ clknet_4_3_0_clk _0095_ VGND VGND VPWR VPWR net91 sky130_fd_sc_hd__dfxtp_2
X_1294_ net110 net112 _0211_ VGND VGND VPWR VPWR _0230_ sky130_fd_sc_hd__mux2_1
XFILLER_0_18_226 VGND VGND VPWR VPWR sky130_fd_sc_hd__decap_3
XFILLER_0_5_164 VGND VGND VPWR VPWR sky130_fd_sc_hd__decap_4
XFILLER_0_26_281 VGND VGND VPWR VPWR sky130_fd_sc_hd__decap_4
XTAP_170 VGND VPWR sky130_fd_sc_hd__tapvpwrvgnd_1
XTAP_181 VGND VPWR sky130_fd_sc_hd__tapvpwrvgnd_1
XTAP_192 VGND VPWR sky130_fd_sc_hd__tapvpwrvgnd_1
X_0932_ cpu.bufreg.i_sh_signed net56 _0420_ VGND VGND VPWR VPWR _0485_ sky130_fd_sc_hd__mux2_1
XFILLER_0_23_55 VGND VGND VPWR VPWR sky130_fd_sc_hd__fill_1
XFILLER_0_2_134 VGND VGND VPWR VPWR sky130_fd_sc_hd__decap_6
XFILLER_0_2_101 VPWR VGND VPWR VGND sky130_ef_sc_hd__decap_12
X_0794_ cpu.alu.i_rs1 _0373_ _0374_ _0375_ _0300_ VGND VGND VPWR VPWR _0376_ sky130_fd_sc_hd__o2111a_1
X_0863_ _0429_ _0426_ _0428_ _0298_ _0300_ VGND VGND VPWR VPWR _0431_ sky130_fd_sc_hd__o32a_1
XFILLER_0_48_85 VGND VGND VPWR VPWR sky130_fd_sc_hd__decap_6
XFILLER_0_48_41 VPWR VGND VPWR VGND sky130_ef_sc_hd__decap_12
XFILLER_0_3_54 VGND VGND VPWR VPWR sky130_fd_sc_hd__fill_2
X_1415_ clknet_4_0_0_clk _0078_ VGND VGND VPWR VPWR net73 sky130_fd_sc_hd__dfxtp_1
X_1346_ clknet_4_9_0_clk _0012_ VGND VGND VPWR VPWR rf_ram_if.rtrig0 sky130_fd_sc_hd__dfxtp_2
X_1277_ _0218_ net6 _0203_ VGND VGND VPWR VPWR _0219_ sky130_fd_sc_hd__mux2_1
XFILLER_0_14_262 VGND VGND VPWR VPWR sky130_fd_sc_hd__fill_2
XFILLER_0_14_273 VGND VGND VPWR VPWR sky130_fd_sc_hd__fill_1
XFILLER_0_52_313 VGND VGND VPWR VPWR sky130_fd_sc_hd__fill_1
X_1200_ _0261_ _0456_ _0397_ VGND VGND VPWR VPWR _0650_ sky130_fd_sc_hd__o21a_1
XFILLER_0_18_66 VGND VGND VPWR VPWR sky130_fd_sc_hd__fill_1
X_1062_ net79 net80 _0550_ VGND VGND VPWR VPWR _0551_ sky130_fd_sc_hd__mux2_1
XFILLER_0_34_76 VGND VGND VPWR VPWR sky130_fd_sc_hd__fill_1
X_1131_ _0601_ VGND VGND VPWR VPWR _0102_ sky130_fd_sc_hd__clkbuf_1
XFILLER_0_50_53 VPWR VGND VPWR VGND sky130_ef_sc_hd__decap_12
XFILLER_0_7_237 VPWR VGND VPWR VGND sky130_ef_sc_hd__decap_12
X_0915_ _0472_ VGND VGND VPWR VPWR _0015_ sky130_fd_sc_hd__clkbuf_1
X_0846_ _0416_ VGND VGND VPWR VPWR net169 sky130_fd_sc_hd__clkbuf_1
X_0777_ cpu.decode.op22 _0358_ VGND VGND VPWR VPWR _0359_ sky130_fd_sc_hd__nor2_1
XFILLER_0_11_276 VGND VGND VPWR VPWR sky130_fd_sc_hd__decap_4
X_1329_ cpu.ctrl.i_jump _0314_ VGND VGND VPWR VPWR _0250_ sky130_fd_sc_hd__and2_1
XFILLER_0_38_107 VPWR VGND VPWR VGND sky130_ef_sc_hd__decap_12
XFILLER_0_46_195 VGND VGND VPWR VPWR sky130_fd_sc_hd__fill_1
Xhold9 cpu.immdec.gen_immdec_w_eq_1.imm11_7\[2\] VGND VGND VPWR VPWR net205 sky130_fd_sc_hd__dlygate4sd3_1
XFILLER_0_52_132 VGND VGND VPWR VPWR sky130_fd_sc_hd__fill_2
X_0700_ cpu.immdec.gen_immdec_w_eq_1.imm11_7\[4\] _0280_ VGND VGND VPWR VPWR _0285_
+ sky130_fd_sc_hd__and2_1
XFILLER_0_37_140 VGND VGND VPWR VPWR sky130_fd_sc_hd__fill_1
XFILLER_0_20_56 VGND VGND VPWR VPWR sky130_fd_sc_hd__fill_1
X_1114_ net120 _0565_ VGND VGND VPWR VPWR _0588_ sky130_fd_sc_hd__nor2_1
X_1045_ net71 net72 _0539_ VGND VGND VPWR VPWR _0542_ sky130_fd_sc_hd__mux2_1
XFILLER_0_0_77 VGND VGND VPWR VPWR sky130_fd_sc_hd__fill_1
XFILLER_0_43_165 VGND VGND VPWR VPWR sky130_fd_sc_hd__decap_3
XFILLER_0_43_132 VGND VGND VPWR VPWR sky130_fd_sc_hd__decap_4
XFILLER_0_43_110 VGND VGND VPWR VPWR sky130_fd_sc_hd__fill_2
XFILLER_0_28_195 VGND VGND VPWR VPWR sky130_fd_sc_hd__fill_1
XFILLER_0_9_97 VPWR VGND VPWR VGND sky130_ef_sc_hd__decap_12
X_0829_ _0295_ _0339_ _0402_ VGND VGND VPWR VPWR _0004_ sky130_fd_sc_hd__o21a_1
XFILLER_0_3_273 VGND VGND VPWR VPWR sky130_fd_sc_hd__decap_6
XFILLER_0_31_88 VGND VGND VPWR VPWR sky130_fd_sc_hd__decap_6
XFILLER_0_31_55 VGND VGND VPWR VPWR sky130_fd_sc_hd__fill_1
XFILLER_0_31_22 VGND VGND VPWR VPWR sky130_fd_sc_hd__decap_8
XFILLER_0_25_143 VGND VGND VPWR VPWR sky130_fd_sc_hd__decap_3
XFILLER_0_25_154 VGND VGND VPWR VPWR sky130_fd_sc_hd__fill_1
X_1028_ net93 net94 _0342_ VGND VGND VPWR VPWR _0533_ sky130_fd_sc_hd__mux2_1
XFILLER_0_31_179 VGND VGND VPWR VPWR sky130_fd_sc_hd__fill_1
XFILLER_0_22_124 VGND VGND VPWR VPWR sky130_fd_sc_hd__fill_1
XFILLER_0_26_88 VPWR VGND VPWR VGND sky130_ef_sc_hd__decap_12
XFILLER_0_42_65 VGND VGND VPWR VPWR sky130_fd_sc_hd__fill_2
XFILLER_0_38_290 VGND VGND VPWR VPWR sky130_fd_sc_hd__fill_2
XFILLER_0_9_129 VGND VGND VPWR VPWR sky130_fd_sc_hd__decap_8
XTAP_396 VGND VPWR sky130_fd_sc_hd__tapvpwrvgnd_1
XTAP_385 VGND VPWR sky130_fd_sc_hd__tapvpwrvgnd_1
XTAP_374 VGND VPWR sky130_fd_sc_hd__tapvpwrvgnd_1
XTAP_363 VGND VPWR sky130_fd_sc_hd__tapvpwrvgnd_1
XTAP_352 VGND VPWR sky130_fd_sc_hd__tapvpwrvgnd_1
XTAP_341 VGND VPWR sky130_fd_sc_hd__tapvpwrvgnd_1
XTAP_330 VGND VPWR sky130_fd_sc_hd__tapvpwrvgnd_1
XFILLER_0_6_76 VGND VGND VPWR VPWR sky130_fd_sc_hd__decap_8
XPHY_69 VGND VGND VPWR VPWR sky130_fd_sc_hd__decap_3
XPHY_58 VGND VGND VPWR VPWR sky130_fd_sc_hd__decap_3
XPHY_14 VGND VGND VPWR VPWR sky130_fd_sc_hd__decap_3
XPHY_25 VGND VGND VPWR VPWR sky130_fd_sc_hd__decap_3
XPHY_36 VGND VGND VPWR VPWR sky130_fd_sc_hd__decap_3
XPHY_47 VGND VGND VPWR VPWR sky130_fd_sc_hd__decap_3
XFILLER_0_51_208 VPWR VGND VPWR VGND sky130_ef_sc_hd__decap_12
XFILLER_0_8_195 VGND VGND VPWR VPWR sky130_fd_sc_hd__fill_1
XFILLER_0_12_13 VPWR VGND VPWR VGND sky130_ef_sc_hd__decap_12
Xoutput119 net119 VGND VGND VPWR VPWR o_dbus_dat[27] sky130_fd_sc_hd__clkbuf_4
Xoutput108 net108 VGND VGND VPWR VPWR o_dbus_dat[17] sky130_fd_sc_hd__clkbuf_4
X_1500_ clknet_4_8_0_clk _0162_ VGND VGND VPWR VPWR net114 sky130_fd_sc_hd__dfxtp_1
Xoutput90 net90 VGND VGND VPWR VPWR o_dbus_adr[30] sky130_fd_sc_hd__clkbuf_4
X_1431_ clknet_4_7_0_clk _0094_ VGND VGND VPWR VPWR net90 sky130_fd_sc_hd__dfxtp_1
X_1362_ clknet_4_7_0_clk _0028_ VGND VGND VPWR VPWR cpu.gen_csr.csr.mcause3_0\[3\]
+ sky130_fd_sc_hd__dfxtp_1
XFILLER_0_37_43 VGND VGND VPWR VPWR sky130_fd_sc_hd__decap_4
X_1293_ _0229_ VGND VGND VPWR VPWR _0158_ sky130_fd_sc_hd__clkbuf_1
XFILLER_0_10_138 VGND VGND VPWR VPWR sky130_fd_sc_hd__fill_2
XFILLER_0_33_219 VGND VGND VPWR VPWR sky130_fd_sc_hd__decap_4
XFILLER_0_18_249 VGND VGND VPWR VPWR sky130_fd_sc_hd__decap_3
XFILLER_0_5_187 VPWR VGND VPWR VGND sky130_ef_sc_hd__decap_12
XTAP_160 VGND VPWR sky130_fd_sc_hd__tapvpwrvgnd_1
XTAP_171 VGND VPWR sky130_fd_sc_hd__tapvpwrvgnd_1
XTAP_182 VGND VPWR sky130_fd_sc_hd__tapvpwrvgnd_1
XTAP_193 VGND VPWR sky130_fd_sc_hd__tapvpwrvgnd_1
X_0931_ _0415_ _0484_ VGND VGND VPWR VPWR _0019_ sky130_fd_sc_hd__nor2_1
X_0862_ _0426_ _0428_ _0429_ VGND VGND VPWR VPWR _0430_ sky130_fd_sc_hd__o21ai_1
XFILLER_0_23_23 VGND VGND VPWR VPWR sky130_fd_sc_hd__fill_1
XFILLER_0_23_89 VGND VGND VPWR VPWR sky130_fd_sc_hd__fill_2
XFILLER_0_2_157 VPWR VGND VPWR VGND sky130_ef_sc_hd__decap_12
XFILLER_0_2_113 VGND VGND VPWR VPWR sky130_fd_sc_hd__decap_4
X_0793_ cpu.alu.i_rs1 _0316_ _0373_ VGND VGND VPWR VPWR _0375_ sky130_fd_sc_hd__nand3_1
XFILLER_0_23_274 VGND VGND VPWR VPWR sky130_fd_sc_hd__decap_6
XFILLER_0_48_53 VPWR VGND VPWR VGND sky130_ef_sc_hd__decap_12
X_1276_ net104 net105 _0211_ VGND VGND VPWR VPWR _0218_ sky130_fd_sc_hd__mux2_1
X_1414_ clknet_4_0_0_clk _0077_ VGND VGND VPWR VPWR net72 sky130_fd_sc_hd__dfxtp_2
X_1345_ clknet_4_10_0_clk _0000_ VGND VGND VPWR VPWR cpu.alu.i_rs1 sky130_fd_sc_hd__dfxtp_2
XFILLER_0_46_300 VGND VGND VPWR VPWR sky130_fd_sc_hd__decap_8
XFILLER_0_14_241 VGND VGND VPWR VPWR sky130_fd_sc_hd__decap_8
XFILLER_0_49_160 VGND VGND VPWR VPWR sky130_fd_sc_hd__decap_8
X_1130_ net123 _0600_ _0574_ VGND VGND VPWR VPWR _0601_ sky130_fd_sc_hd__mux2_1
X_1061_ _0324_ VGND VGND VPWR VPWR _0550_ sky130_fd_sc_hd__clkbuf_4
XFILLER_0_50_65 VPWR VGND VPWR VGND sky130_ef_sc_hd__decap_12
X_0845_ _0415_ cpu.state.ibus_cyc VGND VGND VPWR VPWR _0416_ sky130_fd_sc_hd__and2b_1
XFILLER_0_7_249 VPWR VGND VPWR VGND sky130_ef_sc_hd__decap_12
X_0914_ _0470_ _0461_ _0471_ VGND VGND VPWR VPWR _0472_ sky130_fd_sc_hd__and3b_1
X_0776_ cpu.decode.op26 cpu.decode.co_ebreak _0262_ VGND VGND VPWR VPWR _0358_ sky130_fd_sc_hd__or3b_1
XFILLER_0_11_266 VGND VGND VPWR VPWR sky130_fd_sc_hd__decap_4
XFILLER_0_38_3 VGND VGND VPWR VPWR sky130_fd_sc_hd__fill_2
X_1259_ _0206_ VGND VGND VPWR VPWR _0147_ sky130_fd_sc_hd__clkbuf_1
X_1328_ _0436_ _0249_ _0415_ VGND VGND VPWR VPWR _0173_ sky130_fd_sc_hd__a21oi_1
XFILLER_0_46_163 VGND VGND VPWR VPWR sky130_fd_sc_hd__decap_3
XFILLER_0_46_141 VGND VGND VPWR VPWR sky130_fd_sc_hd__decap_4
XFILLER_0_52_177 VGND VGND VPWR VPWR sky130_fd_sc_hd__fill_1
XFILLER_0_52_111 VGND VGND VPWR VPWR sky130_fd_sc_hd__fill_1
XFILLER_0_37_185 VGND VGND VPWR VPWR sky130_fd_sc_hd__decap_6
XFILLER_0_45_21 VGND VGND VPWR VPWR sky130_fd_sc_hd__decap_6
X_1044_ _0541_ VGND VGND VPWR VPWR _0075_ sky130_fd_sc_hd__clkbuf_1
X_1113_ net119 _0581_ VGND VGND VPWR VPWR _0587_ sky130_fd_sc_hd__nand2_1
XFILLER_0_28_141 VGND VGND VPWR VPWR sky130_fd_sc_hd__fill_2
X_0828_ _0351_ _0355_ _0402_ VGND VGND VPWR VPWR _0003_ sky130_fd_sc_hd__o21a_1
X_0759_ _0288_ _0340_ VGND VGND VPWR VPWR _0341_ sky130_fd_sc_hd__nand2_1
XFILLER_0_40_114 VPWR VGND VPWR VGND sky130_ef_sc_hd__decap_12
XFILLER_0_31_67 VGND VGND VPWR VPWR sky130_fd_sc_hd__fill_1
XFILLER_0_0_233 VGND VGND VPWR VPWR sky130_fd_sc_hd__fill_1
X_1027_ _0532_ VGND VGND VPWR VPWR _0067_ sky130_fd_sc_hd__clkbuf_1
XFILLER_0_39_247 VGND VGND VPWR VPWR sky130_fd_sc_hd__decap_4
XFILLER_0_39_225 VGND VGND VPWR VPWR sky130_fd_sc_hd__decap_6
XFILLER_0_10_309 VGND VGND VPWR VPWR sky130_fd_sc_hd__fill_1
XFILLER_0_22_169 VGND VGND VPWR VPWR sky130_fd_sc_hd__decap_8
XFILLER_0_38_280 VGND VGND VPWR VPWR sky130_fd_sc_hd__fill_1
XFILLER_0_9_119 VGND VGND VPWR VPWR sky130_fd_sc_hd__fill_1
XTAP_397 VGND VPWR sky130_fd_sc_hd__tapvpwrvgnd_1
XTAP_386 VGND VPWR sky130_fd_sc_hd__tapvpwrvgnd_1
XTAP_375 VGND VPWR sky130_fd_sc_hd__tapvpwrvgnd_1
XTAP_364 VGND VPWR sky130_fd_sc_hd__tapvpwrvgnd_1
XTAP_353 VGND VPWR sky130_fd_sc_hd__tapvpwrvgnd_1
XTAP_342 VGND VPWR sky130_fd_sc_hd__tapvpwrvgnd_1
XTAP_331 VGND VPWR sky130_fd_sc_hd__tapvpwrvgnd_1
XTAP_320 VGND VPWR sky130_fd_sc_hd__tapvpwrvgnd_1
XFILLER_0_20_3 VGND VGND VPWR VPWR sky130_fd_sc_hd__fill_2
XFILLER_0_36_206 VGND VGND VPWR VPWR sky130_fd_sc_hd__decap_4
XPHY_59 VGND VGND VPWR VPWR sky130_fd_sc_hd__decap_3
XPHY_15 VGND VGND VPWR VPWR sky130_fd_sc_hd__decap_3
XPHY_26 VGND VGND VPWR VPWR sky130_fd_sc_hd__decap_3
XPHY_37 VGND VGND VPWR VPWR sky130_fd_sc_hd__decap_3
XPHY_48 VGND VGND VPWR VPWR sky130_fd_sc_hd__decap_3
XFILLER_0_44_294 VGND VGND VPWR VPWR sky130_fd_sc_hd__fill_2
XFILLER_0_36_228 VGND VGND VPWR VPWR sky130_fd_sc_hd__decap_6
XFILLER_0_8_141 VGND VGND VPWR VPWR sky130_fd_sc_hd__decap_8
XFILLER_0_12_25 VGND VGND VPWR VPWR sky130_fd_sc_hd__decap_3
XFILLER_0_27_228 VGND VGND VPWR VPWR sky130_fd_sc_hd__decap_8
Xoutput109 net109 VGND VGND VPWR VPWR o_dbus_dat[18] sky130_fd_sc_hd__clkbuf_4
XFILLER_0_50_253 VPWR VGND VPWR VGND sky130_ef_sc_hd__decap_12
X_1430_ clknet_4_5_0_clk _0093_ VGND VGND VPWR VPWR net88 sky130_fd_sc_hd__dfxtp_1
XFILLER_0_10_106 VGND VGND VPWR VPWR sky130_fd_sc_hd__decap_4
Xoutput91 net91 VGND VGND VPWR VPWR o_dbus_adr[31] sky130_fd_sc_hd__clkbuf_4
Xoutput80 net80 VGND VGND VPWR VPWR o_dbus_adr[21] sky130_fd_sc_hd__clkbuf_4
X_1361_ clknet_4_6_0_clk _0027_ VGND VGND VPWR VPWR cpu.gen_csr.csr.mcause3_0\[2\]
+ sky130_fd_sc_hd__dfxtp_1
X_1292_ _0228_ net11 _0590_ VGND VGND VPWR VPWR _0229_ sky130_fd_sc_hd__mux2_1
XFILLER_0_41_297 VGND VGND VPWR VPWR sky130_fd_sc_hd__fill_1
XTAP_150 VGND VPWR sky130_fd_sc_hd__tapvpwrvgnd_1
XFILLER_0_5_199 VPWR VGND VPWR VGND sky130_ef_sc_hd__decap_12
XTAP_161 VGND VPWR sky130_fd_sc_hd__tapvpwrvgnd_1
XTAP_172 VGND VPWR sky130_fd_sc_hd__tapvpwrvgnd_1
XTAP_183 VGND VPWR sky130_fd_sc_hd__tapvpwrvgnd_1
XTAP_194 VGND VPWR sky130_fd_sc_hd__tapvpwrvgnd_1
XFILLER_0_32_253 VPWR VGND VPWR VGND sky130_ef_sc_hd__decap_12
X_0930_ cpu.gen_csr.csr.o_new_irq _0448_ cpu.gen_csr.csr.timer_irq_r _0483_ VGND VGND
+ VPWR VPWR _0484_ sky130_fd_sc_hd__o2bb2a_1
X_0792_ cpu.alu.i_rs1 _0370_ _0372_ _0345_ VGND VGND VPWR VPWR _0374_ sky130_fd_sc_hd__a31o_1
X_0861_ _0370_ _0372_ _0425_ VGND VGND VPWR VPWR _0429_ sky130_fd_sc_hd__and3_1
XFILLER_0_48_65 VPWR VGND VPWR VGND sky130_ef_sc_hd__decap_12
XFILLER_0_2_169 VPWR VGND VPWR VGND sky130_ef_sc_hd__decap_12
X_1413_ clknet_4_2_0_clk _0076_ VGND VGND VPWR VPWR net71 sky130_fd_sc_hd__dfxtp_1
XFILLER_0_23_264 VGND VGND VPWR VPWR sky130_fd_sc_hd__fill_2
X_1275_ _0217_ VGND VGND VPWR VPWR _0152_ sky130_fd_sc_hd__clkbuf_1
X_1344_ clknet_4_14_0_clk _0011_ VGND VGND VPWR VPWR rf_ram_if.wen0_r sky130_fd_sc_hd__dfxtp_1
XFILLER_0_49_172 VPWR VGND VPWR VGND sky130_ef_sc_hd__decap_12
X_1060_ _0549_ VGND VGND VPWR VPWR _0083_ sky130_fd_sc_hd__clkbuf_1
XFILLER_0_18_46 VGND VGND VPWR VPWR sky130_fd_sc_hd__decap_4
XFILLER_0_50_77 VGND VGND VPWR VPWR sky130_fd_sc_hd__decap_6
X_0844_ net67 VGND VGND VPWR VPWR _0415_ sky130_fd_sc_hd__buf_2
X_0775_ _0311_ VGND VGND VPWR VPWR _0357_ sky130_fd_sc_hd__inv_2
X_0913_ _0469_ _0466_ VGND VGND VPWR VPWR _0471_ sky130_fd_sc_hd__nand2_1
XFILLER_0_11_223 VGND VGND VPWR VPWR sky130_fd_sc_hd__fill_1
X_1189_ cpu.immdec.gen_immdec_w_eq_1.imm30_25\[4\] net53 _0614_ VGND VGND VPWR VPWR
+ _0642_ sky130_fd_sc_hd__mux2_1
X_1258_ _0205_ net31 _0203_ VGND VGND VPWR VPWR _0206_ sky130_fd_sc_hd__mux2_1
X_1327_ cpu.state.init_done _0314_ VGND VGND VPWR VPWR _0249_ sky130_fd_sc_hd__nand2_1
XFILLER_0_46_197 VGND VGND VPWR VPWR sky130_fd_sc_hd__decap_6
XFILLER_0_46_175 VPWR VGND VPWR VGND sky130_ef_sc_hd__decap_12
XFILLER_0_52_156 VGND VGND VPWR VPWR sky130_fd_sc_hd__fill_1
XFILLER_0_37_153 VGND VGND VPWR VPWR sky130_fd_sc_hd__fill_1
XFILLER_0_4_209 VGND VGND VPWR VPWR sky130_fd_sc_hd__decap_8
XFILLER_0_45_44 VPWR VGND VPWR VGND sky130_ef_sc_hd__decap_12
X_1043_ net70 net71 _0539_ VGND VGND VPWR VPWR _0541_ sky130_fd_sc_hd__mux2_1
X_1112_ _0579_ net21 _0574_ VGND VGND VPWR VPWR _0586_ sky130_fd_sc_hd__a21boi_1
XFILLER_0_17_9 VGND VGND VPWR VPWR sky130_fd_sc_hd__decap_6
XFILLER_0_28_197 VGND VGND VPWR VPWR sky130_fd_sc_hd__fill_2
XFILLER_0_28_120 VGND VGND VPWR VPWR sky130_fd_sc_hd__decap_3
XFILLER_0_0_35 VGND VGND VPWR VPWR sky130_fd_sc_hd__fill_1
XFILLER_0_0_57 VGND VGND VPWR VPWR sky130_fd_sc_hd__fill_2
XFILLER_0_43_178 VGND VGND VPWR VPWR sky130_fd_sc_hd__fill_2
X_0758_ _0336_ _0338_ _0339_ VGND VGND VPWR VPWR _0340_ sky130_fd_sc_hd__or3_1
X_0827_ _0397_ _0401_ VGND VGND VPWR VPWR _0402_ sky130_fd_sc_hd__and2_2
XFILLER_0_9_55 VGND VGND VPWR VPWR sky130_fd_sc_hd__fill_1
XFILLER_0_9_88 VGND VGND VPWR VPWR sky130_fd_sc_hd__decap_3
XFILLER_0_50_3 VGND VGND VPWR VPWR sky130_fd_sc_hd__fill_2
X_0689_ _0263_ _0268_ _0276_ VGND VGND VPWR VPWR net179 sky130_fd_sc_hd__o21a_1
XFILLER_0_19_120 VGND VGND VPWR VPWR sky130_fd_sc_hd__fill_2
XFILLER_0_22_307 VGND VGND VPWR VPWR sky130_fd_sc_hd__fill_1
XFILLER_0_0_223 VGND VGND VPWR VPWR sky130_fd_sc_hd__fill_1
XFILLER_0_0_212 VGND VGND VPWR VPWR sky130_fd_sc_hd__fill_1
XFILLER_0_0_289 VGND VGND VPWR VPWR sky130_fd_sc_hd__fill_1
X_1026_ net92 net93 _0342_ VGND VGND VPWR VPWR _0532_ sky130_fd_sc_hd__mux2_1
XFILLER_0_8_301 VGND VGND VPWR VPWR sky130_fd_sc_hd__decap_6
XFILLER_0_21_90 VGND VGND VPWR VPWR sky130_fd_sc_hd__fill_2
XFILLER_0_47_281 VPWR VGND VPWR VGND sky130_ef_sc_hd__decap_12
XFILLER_0_9_109 VGND VGND VPWR VPWR sky130_fd_sc_hd__decap_3
XFILLER_0_42_89 VPWR VGND VPWR VGND sky130_ef_sc_hd__decap_12
XTAP_332 VGND VPWR sky130_fd_sc_hd__tapvpwrvgnd_1
XTAP_321 VGND VPWR sky130_fd_sc_hd__tapvpwrvgnd_1
XTAP_310 VGND VPWR sky130_fd_sc_hd__tapvpwrvgnd_1
XTAP_398 VGND VPWR sky130_fd_sc_hd__tapvpwrvgnd_1
XTAP_387 VGND VPWR sky130_fd_sc_hd__tapvpwrvgnd_1
XTAP_376 VGND VPWR sky130_fd_sc_hd__tapvpwrvgnd_1
XTAP_365 VGND VPWR sky130_fd_sc_hd__tapvpwrvgnd_1
XTAP_354 VGND VPWR sky130_fd_sc_hd__tapvpwrvgnd_1
XTAP_343 VGND VPWR sky130_fd_sc_hd__tapvpwrvgnd_1
XFILLER_0_29_281 VGND VGND VPWR VPWR sky130_fd_sc_hd__decap_6
XFILLER_0_29_270 VGND VGND VPWR VPWR sky130_fd_sc_hd__decap_8
XPHY_16 VGND VGND VPWR VPWR sky130_fd_sc_hd__decap_3
X_1009_ net149 _0526_ _0527_ net150 VGND VGND VPWR VPWR _0054_ sky130_fd_sc_hd__a22o_1
XPHY_27 VGND VGND VPWR VPWR sky130_fd_sc_hd__decap_3
XPHY_38 VGND VGND VPWR VPWR sky130_fd_sc_hd__decap_3
XPHY_49 VGND VGND VPWR VPWR sky130_fd_sc_hd__decap_3
XFILLER_0_44_262 VGND VGND VPWR VPWR sky130_fd_sc_hd__decap_4
XFILLER_0_8_197 VPWR VGND VPWR VGND sky130_ef_sc_hd__decap_12
XFILLER_0_50_265 VPWR VGND VPWR VGND sky130_ef_sc_hd__decap_12
XFILLER_0_50_221 VPWR VGND VPWR VGND sky130_ef_sc_hd__decap_12
X_1360_ clknet_4_6_0_clk _0026_ VGND VGND VPWR VPWR cpu.gen_csr.csr.mcause3_0\[1\]
+ sky130_fd_sc_hd__dfxtp_1
Xoutput70 net70 VGND VGND VPWR VPWR o_dbus_adr[11] sky130_fd_sc_hd__clkbuf_4
X_1291_ net109 net110 _0211_ VGND VGND VPWR VPWR _0228_ sky130_fd_sc_hd__mux2_1
Xoutput92 net92 VGND VGND VPWR VPWR o_dbus_adr[3] sky130_fd_sc_hd__clkbuf_4
Xoutput81 net81 VGND VGND VPWR VPWR o_dbus_adr[22] sky130_fd_sc_hd__clkbuf_4
XFILLER_0_41_243 VGND VGND VPWR VPWR sky130_fd_sc_hd__fill_2
X_1489_ clknet_4_7_0_clk _0151_ VGND VGND VPWR VPWR net102 sky130_fd_sc_hd__dfxtp_1
XTAP_151 VGND VPWR sky130_fd_sc_hd__tapvpwrvgnd_1
XTAP_140 VGND VPWR sky130_fd_sc_hd__tapvpwrvgnd_1
XTAP_162 VGND VPWR sky130_fd_sc_hd__tapvpwrvgnd_1
XTAP_173 VGND VPWR sky130_fd_sc_hd__tapvpwrvgnd_1
XTAP_184 VGND VPWR sky130_fd_sc_hd__tapvpwrvgnd_1
XTAP_195 VGND VPWR sky130_fd_sc_hd__tapvpwrvgnd_1
XFILLER_0_32_265 VGND VGND VPWR VPWR sky130_fd_sc_hd__fill_1
XFILLER_0_32_210 VGND VGND VPWR VPWR sky130_fd_sc_hd__decap_8
XFILLER_0_23_47 VGND VGND VPWR VPWR sky130_fd_sc_hd__fill_2
X_0791_ _0370_ _0372_ VGND VGND VPWR VPWR _0373_ sky130_fd_sc_hd__and2_1
X_0860_ _0381_ _0383_ _0384_ _0427_ _0379_ VGND VGND VPWR VPWR _0428_ sky130_fd_sc_hd__o311a_1
XFILLER_0_48_77 VGND VGND VPWR VPWR sky130_fd_sc_hd__decap_6
XFILLER_0_47_9 VPWR VGND VPWR VGND sky130_ef_sc_hd__decap_12
X_1343_ clknet_4_7_0_clk _0010_ VGND VGND VPWR VPWR cpu.state.ibus_cyc sky130_fd_sc_hd__dfxtp_1
X_1412_ clknet_4_2_0_clk _0075_ VGND VGND VPWR VPWR net70 sky130_fd_sc_hd__dfxtp_1
X_1274_ _0216_ net5 _0203_ VGND VGND VPWR VPWR _0217_ sky130_fd_sc_hd__mux2_1
XFILLER_0_3_57 VPWR VGND VPWR VGND sky130_ef_sc_hd__decap_12
XFILLER_0_46_313 VGND VGND VPWR VPWR sky130_fd_sc_hd__fill_1
X_0989_ net163 _0520_ _0523_ net164 VGND VGND VPWR VPWR _0038_ sky130_fd_sc_hd__a22o_1
XFILLER_0_49_184 VPWR VGND VPWR VGND sky130_ef_sc_hd__decap_12
XFILLER_0_9_281 VPWR VGND VPWR VGND sky130_ef_sc_hd__decap_12
XFILLER_0_20_257 VGND VGND VPWR VPWR sky130_fd_sc_hd__fill_1
XFILLER_0_50_23 VGND VGND VPWR VPWR sky130_fd_sc_hd__decap_4
XFILLER_0_28_313 VGND VGND VPWR VPWR sky130_fd_sc_hd__fill_1
XFILLER_0_28_302 VGND VGND VPWR VPWR sky130_fd_sc_hd__decap_6
X_0912_ _0469_ _0466_ VGND VGND VPWR VPWR _0470_ sky130_fd_sc_hd__nor2_1
X_0843_ _0414_ VGND VGND VPWR VPWR net99 sky130_fd_sc_hd__clkbuf_1
X_0774_ _0354_ _0355_ VGND VGND VPWR VPWR _0356_ sky130_fd_sc_hd__nor2_1
X_1326_ _0248_ VGND VGND VPWR VPWR _0172_ sky130_fd_sc_hd__clkbuf_1
X_1188_ _0641_ VGND VGND VPWR VPWR _0119_ sky130_fd_sc_hd__clkbuf_1
X_1257_ net129 net130 _0189_ VGND VGND VPWR VPWR _0205_ sky130_fd_sc_hd__mux2_1
XFILLER_0_19_313 VGND VGND VPWR VPWR sky130_fd_sc_hd__fill_1
XFILLER_0_46_187 VGND VGND VPWR VPWR sky130_fd_sc_hd__decap_8
XFILLER_0_34_305 VGND VGND VPWR VPWR sky130_fd_sc_hd__decap_3
X_1111_ net118 _0574_ _0584_ _0585_ VGND VGND VPWR VPWR _0098_ sky130_fd_sc_hd__o22a_1
X_1042_ _0540_ VGND VGND VPWR VPWR _0074_ sky130_fd_sc_hd__clkbuf_1
Xmax_cap1 _0411_ VGND VGND VPWR VPWR net196 sky130_fd_sc_hd__buf_1
XFILLER_0_43_113 VGND VGND VPWR VPWR sky130_fd_sc_hd__decap_4
XFILLER_0_31_308 VGND VGND VPWR VPWR sky130_fd_sc_hd__decap_3
XFILLER_0_28_176 VGND VGND VPWR VPWR sky130_fd_sc_hd__decap_4
XFILLER_0_0_69 VGND VGND VPWR VPWR sky130_fd_sc_hd__fill_2
X_0688_ _0276_ cpu.immdec.gen_immdec_w_eq_1.imm24_20\[4\] _0269_ _0279_ VGND VGND
+ VPWR VPWR net178 sky130_fd_sc_hd__a31o_1
X_0826_ _0320_ _0321_ VGND VGND VPWR VPWR _0401_ sky130_fd_sc_hd__nand2_4
X_0757_ _0297_ _0335_ VGND VGND VPWR VPWR _0339_ sky130_fd_sc_hd__nor2_1
XFILLER_0_43_3 VPWR VGND VPWR VGND sky130_ef_sc_hd__decap_12
X_1309_ _0310_ _0312_ VGND VGND VPWR VPWR _0240_ sky130_fd_sc_hd__xnor2_1
Xclkbuf_4_15_0_clk clknet_0_clk VGND VGND VPWR VPWR clknet_4_15_0_clk sky130_fd_sc_hd__clkbuf_8
XFILLER_0_34_179 VGND VGND VPWR VPWR sky130_fd_sc_hd__decap_4
XFILLER_0_25_113 VGND VGND VPWR VPWR sky130_fd_sc_hd__decap_4
XFILLER_0_25_135 VGND VGND VPWR VPWR sky130_fd_sc_hd__decap_4
XFILLER_0_40_105 VGND VGND VPWR VPWR sky130_fd_sc_hd__fill_1
XFILLER_0_0_279 VGND VGND VPWR VPWR sky130_fd_sc_hd__fill_1
XFILLER_0_0_268 VGND VGND VPWR VPWR sky130_fd_sc_hd__fill_1
XFILLER_0_48_249 VGND VGND VPWR VPWR sky130_fd_sc_hd__decap_3
X_1025_ _0531_ VGND VGND VPWR VPWR _0066_ sky130_fd_sc_hd__clkbuf_1
XFILLER_0_8_313 VGND VGND VPWR VPWR sky130_fd_sc_hd__fill_1
X_0809_ _0266_ _0341_ _0343_ _0390_ VGND VGND VPWR VPWR cpu.o_wdata0 sky130_fd_sc_hd__a31o_1
XFILLER_0_16_168 VGND VGND VPWR VPWR sky130_fd_sc_hd__fill_1
XFILLER_0_47_293 VPWR VGND VPWR VGND sky130_ef_sc_hd__decap_12
XFILLER_0_30_171 VGND VGND VPWR VPWR sky130_fd_sc_hd__decap_8
XFILLER_0_22_149 VGND VGND VPWR VPWR sky130_fd_sc_hd__decap_3
XFILLER_0_30_193 VGND VGND VPWR VPWR sky130_fd_sc_hd__decap_3
XFILLER_0_45_208 VGND VGND VPWR VPWR sky130_fd_sc_hd__fill_1
XFILLER_0_42_24 VGND VGND VPWR VPWR sky130_fd_sc_hd__fill_1
XANTENNA_1 net43 VGND VGND VPWR VPWR sky130_fd_sc_hd__diode_2
XFILLER_0_5_305 VGND VGND VPWR VPWR sky130_fd_sc_hd__decap_4
XFILLER_0_13_105 VGND VGND VPWR VPWR sky130_fd_sc_hd__decap_4
XTAP_366 VGND VPWR sky130_fd_sc_hd__tapvpwrvgnd_1
XTAP_355 VGND VPWR sky130_fd_sc_hd__tapvpwrvgnd_1
XTAP_344 VGND VPWR sky130_fd_sc_hd__tapvpwrvgnd_1
XTAP_333 VGND VPWR sky130_fd_sc_hd__tapvpwrvgnd_1
XTAP_322 VGND VPWR sky130_fd_sc_hd__tapvpwrvgnd_1
XTAP_311 VGND VPWR sky130_fd_sc_hd__tapvpwrvgnd_1
XTAP_300 VGND VPWR sky130_fd_sc_hd__tapvpwrvgnd_1
XTAP_399 VGND VPWR sky130_fd_sc_hd__tapvpwrvgnd_1
XTAP_388 VGND VPWR sky130_fd_sc_hd__tapvpwrvgnd_1
XTAP_377 VGND VPWR sky130_fd_sc_hd__tapvpwrvgnd_1
XPHY_17 VGND VGND VPWR VPWR sky130_fd_sc_hd__decap_3
XPHY_28 VGND VGND VPWR VPWR sky130_fd_sc_hd__decap_3
XFILLER_0_29_260 VGND VGND VPWR VPWR sky130_fd_sc_hd__decap_6
XPHY_39 VGND VGND VPWR VPWR sky130_fd_sc_hd__decap_3
X_1008_ _0522_ VGND VGND VPWR VPWR _0527_ sky130_fd_sc_hd__buf_2
XFILLER_0_12_171 VPWR VGND VPWR VGND sky130_ef_sc_hd__decap_12
XFILLER_0_50_233 VPWR VGND VPWR VGND sky130_ef_sc_hd__decap_12
Xoutput93 net93 VGND VGND VPWR VPWR o_dbus_adr[4] sky130_fd_sc_hd__clkbuf_4
Xoutput82 net82 VGND VGND VPWR VPWR o_dbus_adr[23] sky130_fd_sc_hd__clkbuf_4
XFILLER_0_50_277 VPWR VGND VPWR VGND sky130_ef_sc_hd__decap_12
Xoutput71 net71 VGND VGND VPWR VPWR o_dbus_adr[12] sky130_fd_sc_hd__clkbuf_4
X_1290_ _0227_ VGND VGND VPWR VPWR _0157_ sky130_fd_sc_hd__clkbuf_1
XFILLER_0_37_57 VPWR VGND VPWR VGND sky130_ef_sc_hd__decap_12
XFILLER_0_26_241 VGND VGND VPWR VPWR sky130_fd_sc_hd__decap_6
XFILLER_0_26_285 VGND VGND VPWR VPWR sky130_fd_sc_hd__fill_1
X_1488_ clknet_4_7_0_clk _0150_ VGND VGND VPWR VPWR net101 sky130_fd_sc_hd__dfxtp_1
XTAP_141 VGND VPWR sky130_fd_sc_hd__tapvpwrvgnd_1
XTAP_130 VGND VPWR sky130_fd_sc_hd__tapvpwrvgnd_1
XTAP_152 VGND VPWR sky130_fd_sc_hd__tapvpwrvgnd_1
XTAP_163 VGND VPWR sky130_fd_sc_hd__tapvpwrvgnd_1
XTAP_174 VGND VPWR sky130_fd_sc_hd__tapvpwrvgnd_1
XTAP_185 VGND VPWR sky130_fd_sc_hd__tapvpwrvgnd_1
XTAP_196 VGND VPWR sky130_fd_sc_hd__tapvpwrvgnd_1
XFILLER_0_32_244 VGND VGND VPWR VPWR sky130_fd_sc_hd__decap_8
X_0790_ _0371_ _0365_ VGND VGND VPWR VPWR _0372_ sky130_fd_sc_hd__or2_2
X_1273_ net103 net104 _0211_ VGND VGND VPWR VPWR _0216_ sky130_fd_sc_hd__mux2_1
X_1411_ clknet_4_2_0_clk _0074_ VGND VGND VPWR VPWR net69 sky130_fd_sc_hd__dfxtp_1
X_1342_ clknet_4_11_0_clk _0009_ VGND VGND VPWR VPWR rf_ram_if.rdata1 sky130_fd_sc_hd__dfxtp_1
XFILLER_0_3_69 VPWR VGND VPWR VGND sky130_ef_sc_hd__decap_12
X_0988_ net162 _0520_ _0523_ net163 VGND VGND VPWR VPWR _0037_ sky130_fd_sc_hd__a22o_1
XFILLER_0_49_196 VPWR VGND VPWR VGND sky130_ef_sc_hd__decap_12
XFILLER_0_52_306 VGND VGND VPWR VPWR sky130_fd_sc_hd__fill_2
XFILLER_0_9_293 VPWR VGND VPWR VGND sky130_ef_sc_hd__decap_12
XFILLER_0_34_58 VGND VGND VPWR VPWR sky130_fd_sc_hd__fill_2
X_0911_ net173 VGND VGND VPWR VPWR _0469_ sky130_fd_sc_hd__inv_2
X_0842_ cpu.state.init_done _0411_ _0412_ _0413_ VGND VGND VPWR VPWR _0414_ sky130_fd_sc_hd__and4_1
X_0773_ cpu.state.cnt_r\[2\] _0337_ _0353_ VGND VGND VPWR VPWR _0355_ sky130_fd_sc_hd__and3_1
XFILLER_0_11_203 VPWR VGND VPWR VGND sky130_ef_sc_hd__decap_12
X_1325_ net67 cpu.state.cnt_r\[2\] VGND VGND VPWR VPWR _0248_ sky130_fd_sc_hd__and2b_1
X_1256_ _0204_ VGND VGND VPWR VPWR _0146_ sky130_fd_sc_hd__clkbuf_1
X_1187_ cpu.immdec.gen_immdec_w_eq_1.imm30_25\[2\] _0640_ _0636_ VGND VGND VPWR VPWR
+ _0641_ sky130_fd_sc_hd__mux2_1
XFILLER_0_52_125 VGND VGND VPWR VPWR sky130_fd_sc_hd__decap_4
XFILLER_0_52_169 VGND VGND VPWR VPWR sky130_fd_sc_hd__fill_2
XFILLER_0_40_309 VGND VGND VPWR VPWR sky130_fd_sc_hd__fill_1
X_1110_ _0579_ net20 _0574_ VGND VGND VPWR VPWR _0585_ sky130_fd_sc_hd__a21bo_1
XFILLER_0_45_57 VPWR VGND VPWR VGND sky130_ef_sc_hd__decap_12
X_1041_ net69 net70 _0539_ VGND VGND VPWR VPWR _0540_ sky130_fd_sc_hd__mux2_1
XFILLER_0_43_169 VGND VGND VPWR VPWR sky130_fd_sc_hd__fill_1
XFILLER_0_43_103 VGND VGND VPWR VPWR sky130_fd_sc_hd__fill_1
XFILLER_0_28_155 VGND VGND VPWR VPWR sky130_fd_sc_hd__decap_4
XFILLER_0_3_200 VPWR VGND VPWR VGND sky130_ef_sc_hd__decap_12
XFILLER_0_9_57 VGND VGND VPWR VPWR sky130_fd_sc_hd__decap_6
X_0825_ _0400_ _0399_ _0298_ VGND VGND VPWR VPWR net133 sky130_fd_sc_hd__a21o_1
X_0756_ cpu.state.cnt_r\[0\] _0337_ VGND VGND VPWR VPWR _0338_ sky130_fd_sc_hd__and2_1
X_0687_ _0252_ cpu.immdec.gen_immdec_w_eq_1.imm19_12_20\[8\] VGND VGND VPWR VPWR _0279_
+ sky130_fd_sc_hd__and2b_1
XFILLER_0_36_3 VGND VGND VPWR VPWR sky130_fd_sc_hd__decap_3
X_1308_ _0239_ VGND VGND VPWR VPWR _0163_ sky130_fd_sc_hd__clkbuf_1
X_1239_ _0192_ net13 _0579_ VGND VGND VPWR VPWR _0193_ sky130_fd_sc_hd__mux2_1
XFILLER_0_19_177 VGND VGND VPWR VPWR sky130_fd_sc_hd__fill_1
XFILLER_0_22_309 VGND VGND VPWR VPWR sky130_fd_sc_hd__fill_1
XFILLER_0_15_16 VPWR VGND VPWR VGND sky130_ef_sc_hd__decap_12
XFILLER_0_0_247 VGND VGND VPWR VPWR sky130_fd_sc_hd__fill_1
XFILLER_0_0_225 VGND VGND VPWR VPWR sky130_fd_sc_hd__fill_2
X_1024_ net89 net92 _0342_ VGND VGND VPWR VPWR _0531_ sky130_fd_sc_hd__mux2_1
XFILLER_0_31_106 VGND VGND VPWR VPWR sky130_fd_sc_hd__decap_6
X_0808_ _0344_ _0369_ _0389_ _0272_ VGND VGND VPWR VPWR _0390_ sky130_fd_sc_hd__o31a_1
XFILLER_0_16_125 VGND VGND VPWR VPWR sky130_fd_sc_hd__decap_8
XFILLER_0_16_136 VGND VGND VPWR VPWR sky130_fd_sc_hd__decap_4
XFILLER_0_16_147 VGND VGND VPWR VPWR sky130_fd_sc_hd__fill_1
X_0739_ cpu.decode.opcode\[2\] _0308_ VGND VGND VPWR VPWR _0321_ sky130_fd_sc_hd__nand2_1
XFILLER_0_15_191 VGND VGND VPWR VPWR sky130_fd_sc_hd__fill_1
XFILLER_0_22_139 VGND VGND VPWR VPWR sky130_fd_sc_hd__fill_1
XANTENNA_2 net72 VGND VGND VPWR VPWR sky130_fd_sc_hd__diode_2
Xclkbuf_4_14_0_clk clknet_0_clk VGND VGND VPWR VPWR clknet_4_14_0_clk sky130_fd_sc_hd__clkbuf_8
XTAP_389 VGND VPWR sky130_fd_sc_hd__tapvpwrvgnd_1
XTAP_378 VGND VPWR sky130_fd_sc_hd__tapvpwrvgnd_1
XTAP_367 VGND VPWR sky130_fd_sc_hd__tapvpwrvgnd_1
XTAP_356 VGND VPWR sky130_fd_sc_hd__tapvpwrvgnd_1
XTAP_345 VGND VPWR sky130_fd_sc_hd__tapvpwrvgnd_1
XTAP_334 VGND VPWR sky130_fd_sc_hd__tapvpwrvgnd_1
XTAP_323 VGND VPWR sky130_fd_sc_hd__tapvpwrvgnd_1
XTAP_312 VGND VPWR sky130_fd_sc_hd__tapvpwrvgnd_1
XTAP_301 VGND VPWR sky130_fd_sc_hd__tapvpwrvgnd_1
XPHY_18 VGND VGND VPWR VPWR sky130_fd_sc_hd__decap_3
XPHY_29 VGND VGND VPWR VPWR sky130_fd_sc_hd__decap_3
X_1007_ _0453_ VGND VGND VPWR VPWR _0526_ sky130_fd_sc_hd__buf_2
XFILLER_0_8_177 VPWR VGND VPWR VGND sky130_ef_sc_hd__decap_12
XFILLER_0_44_286 VGND VGND VPWR VPWR sky130_fd_sc_hd__decap_8
XFILLER_0_12_183 VGND VGND VPWR VPWR sky130_fd_sc_hd__decap_3
XFILLER_0_50_245 VGND VGND VPWR VPWR sky130_fd_sc_hd__decap_6
Xoutput72 net72 VGND VGND VPWR VPWR o_dbus_adr[13] sky130_fd_sc_hd__clkbuf_4
XFILLER_0_50_289 VGND VGND VPWR VPWR sky130_fd_sc_hd__decap_4
XFILLER_0_37_25 VGND VGND VPWR VPWR sky130_fd_sc_hd__fill_2
Xoutput94 net94 VGND VGND VPWR VPWR o_dbus_adr[5] sky130_fd_sc_hd__clkbuf_4
Xoutput83 net83 VGND VGND VPWR VPWR o_dbus_adr[24] sky130_fd_sc_hd__clkbuf_4
XFILLER_0_37_69 VGND VGND VPWR VPWR sky130_fd_sc_hd__decap_4
XFILLER_0_41_278 VGND VGND VPWR VPWR sky130_fd_sc_hd__fill_2
X_1487_ clknet_4_15_0_clk _0149_ VGND VGND VPWR VPWR net131 sky130_fd_sc_hd__dfxtp_1
XTAP_142 VGND VPWR sky130_fd_sc_hd__tapvpwrvgnd_1
XTAP_131 VGND VPWR sky130_fd_sc_hd__tapvpwrvgnd_1
XTAP_120 VGND VPWR sky130_fd_sc_hd__tapvpwrvgnd_1
XTAP_153 VGND VPWR sky130_fd_sc_hd__tapvpwrvgnd_1
XTAP_164 VGND VPWR sky130_fd_sc_hd__tapvpwrvgnd_1
XTAP_175 VGND VPWR sky130_fd_sc_hd__tapvpwrvgnd_1
XTAP_186 VGND VPWR sky130_fd_sc_hd__tapvpwrvgnd_1
XTAP_197 VGND VPWR sky130_fd_sc_hd__tapvpwrvgnd_1
XFILLER_0_49_301 VGND VGND VPWR VPWR sky130_fd_sc_hd__fill_1
XFILLER_0_32_278 VGND VGND VPWR VPWR sky130_fd_sc_hd__decap_4
X_1410_ clknet_4_0_0_clk _0073_ VGND VGND VPWR VPWR net98 sky130_fd_sc_hd__dfxtp_1
XFILLER_0_23_223 VGND VGND VPWR VPWR sky130_fd_sc_hd__fill_1
XFILLER_0_23_256 VGND VGND VPWR VPWR sky130_fd_sc_hd__decap_8
X_1272_ _0215_ VGND VGND VPWR VPWR _0151_ sky130_fd_sc_hd__clkbuf_1
X_1341_ clknet_4_4_0_clk _0008_ VGND VGND VPWR VPWR rf_ram_if.rgnt sky130_fd_sc_hd__dfxtp_1
X_0987_ net159 _0520_ _0523_ net162 VGND VGND VPWR VPWR _0036_ sky130_fd_sc_hd__a22o_1
XFILLER_0_1_172 VPWR VGND VPWR VGND sky130_ef_sc_hd__decap_12
XFILLER_0_9_261 VPWR VGND VPWR VGND sky130_ef_sc_hd__decap_12
XFILLER_0_18_27 VGND VGND VPWR VPWR sky130_fd_sc_hd__fill_1
X_0772_ cpu.state.cnt_r\[2\] _0337_ _0353_ VGND VGND VPWR VPWR _0354_ sky130_fd_sc_hd__a21oi_1
XFILLER_0_7_209 VPWR VGND VPWR VGND sky130_ef_sc_hd__decap_12
X_0910_ _0468_ VGND VGND VPWR VPWR _0014_ sky130_fd_sc_hd__clkbuf_1
X_0841_ cpu.bufreg.data\[0\] _0257_ _0316_ _0400_ VGND VGND VPWR VPWR _0413_ sky130_fd_sc_hd__o2bb2a_1
XFILLER_0_52_9 VGND VGND VPWR VPWR sky130_fd_sc_hd__fill_1
XFILLER_0_11_215 VGND VGND VPWR VPWR sky130_fd_sc_hd__decap_4
X_1324_ _0247_ VGND VGND VPWR VPWR _0171_ sky130_fd_sc_hd__clkbuf_1
X_1186_ cpu.immdec.gen_immdec_w_eq_1.imm30_25\[3\] net52 _0614_ VGND VGND VPWR VPWR
+ _0640_ sky130_fd_sc_hd__mux2_1
X_1255_ _0202_ net30 _0203_ VGND VGND VPWR VPWR _0204_ sky130_fd_sc_hd__mux2_1
XFILLER_0_6_253 VPWR VGND VPWR VGND sky130_ef_sc_hd__decap_12
XFILLER_0_37_167 VGND VGND VPWR VPWR sky130_fd_sc_hd__fill_1
XFILLER_0_37_134 VGND VGND VPWR VPWR sky130_fd_sc_hd__fill_1
XFILLER_0_45_69 VGND VGND VPWR VPWR sky130_fd_sc_hd__decap_4
X_1040_ _0324_ VGND VGND VPWR VPWR _0539_ sky130_fd_sc_hd__clkbuf_8
XFILLER_0_0_49 VGND VGND VPWR VPWR sky130_fd_sc_hd__fill_1
XFILLER_0_51_181 VPWR VGND VPWR VGND sky130_ef_sc_hd__decap_12
X_0755_ _0311_ _0312_ cpu.bufreg2.i_bytecnt\[0\] VGND VGND VPWR VPWR _0337_ sky130_fd_sc_hd__nor3_2
XFILLER_0_28_189 VGND VGND VPWR VPWR sky130_fd_sc_hd__decap_6
XFILLER_0_3_212 VPWR VGND VPWR VGND sky130_ef_sc_hd__decap_12
X_0824_ _0400_ cpu.bufreg.data\[0\] _0316_ VGND VGND VPWR VPWR net134 sky130_fd_sc_hd__o21ai_2
X_0686_ _0276_ cpu.immdec.gen_immdec_w_eq_1.imm24_20\[3\] _0269_ _0278_ VGND VGND
+ VPWR VPWR net177 sky130_fd_sc_hd__a31o_1
XFILLER_0_10_94 VPWR VGND VPWR VGND sky130_ef_sc_hd__decap_12
X_1307_ _0238_ net17 _0590_ VGND VGND VPWR VPWR _0239_ sky130_fd_sc_hd__mux2_1
X_1238_ net111 net122 _0189_ VGND VGND VPWR VPWR _0192_ sky130_fd_sc_hd__mux2_1
X_1169_ _0300_ _0261_ cpu.immdec.gen_immdec_w_eq_1.imm31 VGND VGND VPWR VPWR _0627_
+ sky130_fd_sc_hd__a21bo_1
XFILLER_0_19_134 VPWR VGND VPWR VGND sky130_ef_sc_hd__decap_12
XFILLER_0_19_156 VPWR VGND VPWR VGND sky130_ef_sc_hd__decap_12
XFILLER_0_42_192 VGND VGND VPWR VPWR sky130_fd_sc_hd__decap_4
XFILLER_0_15_28 VGND VGND VPWR VPWR sky130_fd_sc_hd__decap_6
X_1023_ net161 _0453_ _0522_ _0530_ VGND VGND VPWR VPWR _0065_ sky130_fd_sc_hd__a22o_1
XFILLER_0_31_118 VGND VGND VPWR VPWR sky130_fd_sc_hd__decap_3
XFILLER_0_21_82 VGND VGND VPWR VPWR sky130_fd_sc_hd__decap_8
X_0807_ _0377_ _0387_ _0290_ _0307_ _0388_ VGND VGND VPWR VPWR _0389_ sky130_fd_sc_hd__o2111a_1
X_0738_ cpu.state.init_done cpu.gen_csr.csr.o_new_irq VGND VGND VPWR VPWR _0320_ sky130_fd_sc_hd__nor2_1
X_0669_ cpu.state.gen_csr.misalign_trap_sync_r _0264_ VGND VGND VPWR VPWR _0265_ sky130_fd_sc_hd__or2_1
XFILLER_0_30_162 VGND VGND VPWR VPWR sky130_fd_sc_hd__decap_4
XFILLER_0_42_48 VPWR VGND VPWR VGND sky130_ef_sc_hd__decap_12
XFILLER_0_38_251 VGND VGND VPWR VPWR sky130_fd_sc_hd__fill_1
XFILLER_0_21_151 VPWR VGND VPWR VGND sky130_ef_sc_hd__decap_12
XTAP_379 VGND VPWR sky130_fd_sc_hd__tapvpwrvgnd_1
XTAP_368 VGND VPWR sky130_fd_sc_hd__tapvpwrvgnd_1
XTAP_357 VGND VPWR sky130_fd_sc_hd__tapvpwrvgnd_1
XTAP_346 VGND VPWR sky130_fd_sc_hd__tapvpwrvgnd_1
XTAP_335 VGND VPWR sky130_fd_sc_hd__tapvpwrvgnd_1
XTAP_324 VGND VPWR sky130_fd_sc_hd__tapvpwrvgnd_1
XTAP_313 VGND VPWR sky130_fd_sc_hd__tapvpwrvgnd_1
XTAP_302 VGND VPWR sky130_fd_sc_hd__tapvpwrvgnd_1
XFILLER_0_29_240 VGND VGND VPWR VPWR sky130_fd_sc_hd__decap_6
XPHY_19 VGND VGND VPWR VPWR sky130_fd_sc_hd__decap_3
XFILLER_0_13_6 VGND VGND VPWR VPWR sky130_fd_sc_hd__fill_2
X_1006_ net147 _0524_ _0525_ net149 VGND VGND VPWR VPWR _0053_ sky130_fd_sc_hd__a22o_1
XFILLER_0_8_156 VGND VGND VPWR VPWR sky130_fd_sc_hd__fill_2
XFILLER_0_8_189 VGND VGND VPWR VPWR sky130_fd_sc_hd__decap_6
XFILLER_0_12_195 VGND VGND VPWR VPWR sky130_fd_sc_hd__fill_1
XFILLER_0_12_29 VGND VGND VPWR VPWR sky130_fd_sc_hd__decap_6
XFILLER_0_35_243 VGND VGND VPWR VPWR sky130_fd_sc_hd__fill_2
Xoutput95 net95 VGND VGND VPWR VPWR o_dbus_adr[6] sky130_fd_sc_hd__clkbuf_4
Xoutput73 net73 VGND VGND VPWR VPWR o_dbus_adr[14] sky130_fd_sc_hd__clkbuf_4
Xoutput84 net84 VGND VGND VPWR VPWR o_dbus_adr[25] sky130_fd_sc_hd__clkbuf_4
XTAP_132 VGND VPWR sky130_fd_sc_hd__tapvpwrvgnd_1
XTAP_121 VGND VPWR sky130_fd_sc_hd__tapvpwrvgnd_1
XTAP_110 VGND VPWR sky130_fd_sc_hd__tapvpwrvgnd_1
XTAP_143 VGND VPWR sky130_fd_sc_hd__tapvpwrvgnd_1
XTAP_154 VGND VPWR sky130_fd_sc_hd__tapvpwrvgnd_1
XTAP_165 VGND VPWR sky130_fd_sc_hd__tapvpwrvgnd_1
XTAP_176 VGND VPWR sky130_fd_sc_hd__tapvpwrvgnd_1
X_1486_ clknet_4_10_0_clk _0148_ VGND VGND VPWR VPWR net130 sky130_fd_sc_hd__dfxtp_1
XTAP_187 VGND VPWR sky130_fd_sc_hd__tapvpwrvgnd_1
XTAP_198 VGND VPWR sky130_fd_sc_hd__tapvpwrvgnd_1
XFILLER_0_43_80 VGND VGND VPWR VPWR sky130_fd_sc_hd__decap_4
XFILLER_0_32_224 VGND VGND VPWR VPWR sky130_fd_sc_hd__decap_4
Xclkbuf_4_13_0_clk clknet_0_clk VGND VGND VPWR VPWR clknet_4_13_0_clk sky130_fd_sc_hd__clkbuf_8
XFILLER_0_7_91 VGND VGND VPWR VPWR sky130_fd_sc_hd__decap_3
XFILLER_0_2_129 VGND VGND VPWR VPWR sky130_fd_sc_hd__fill_2
X_1340_ clknet_4_11_0_clk net200 VGND VGND VPWR VPWR rf_ram_if.rtrig1 sky130_fd_sc_hd__dfxtp_1
X_1271_ _0214_ net4 _0203_ VGND VGND VPWR VPWR _0215_ sky130_fd_sc_hd__mux2_1
X_0986_ net148 _0520_ _0523_ net159 VGND VGND VPWR VPWR _0035_ sky130_fd_sc_hd__a22o_1
X_1469_ clknet_4_12_0_clk _0131_ VGND VGND VPWR VPWR cpu.decode.co_ebreak sky130_fd_sc_hd__dfxtp_2
XFILLER_0_1_184 VPWR VGND VPWR VGND sky130_ef_sc_hd__decap_12
XFILLER_0_37_305 VGND VGND VPWR VPWR sky130_fd_sc_hd__decap_4
XFILLER_0_9_273 VGND VGND VPWR VPWR sky130_fd_sc_hd__decap_6
XFILLER_0_0_3 VGND VGND VPWR VPWR sky130_fd_sc_hd__decap_4
XFILLER_0_34_27 VGND VGND VPWR VPWR sky130_fd_sc_hd__fill_1
X_0771_ _0351_ _0352_ VGND VGND VPWR VPWR _0353_ sky130_fd_sc_hd__nor2_1
X_0840_ _0288_ _0388_ VGND VGND VPWR VPWR _0412_ sky130_fd_sc_hd__nor2_1
XFILLER_0_45_9 VPWR VGND VPWR VGND sky130_ef_sc_hd__decap_12
X_1323_ net67 cpu.state.cnt_r\[1\] VGND VGND VPWR VPWR _0247_ sky130_fd_sc_hd__and2b_1
X_1254_ _0567_ VGND VGND VPWR VPWR _0203_ sky130_fd_sc_hd__buf_4
X_1185_ _0639_ VGND VGND VPWR VPWR _0118_ sky130_fd_sc_hd__clkbuf_1
XFILLER_0_40_81 VGND VGND VPWR VPWR sky130_fd_sc_hd__decap_3
X_0969_ _0511_ cpu.immdec.gen_immdec_w_eq_1.imm11_7\[0\] _0512_ VGND VGND VPWR VPWR
+ _0513_ sky130_fd_sc_hd__mux2_1
XFILLER_0_6_265 VPWR VGND VPWR VGND sky130_ef_sc_hd__decap_12
XFILLER_0_52_149 VGND VGND VPWR VPWR sky130_fd_sc_hd__fill_1
XFILLER_0_29_16 VGND VGND VPWR VPWR sky130_fd_sc_hd__fill_1
X_0685_ _0252_ cpu.immdec.gen_immdec_w_eq_1.imm19_12_20\[7\] VGND VGND VPWR VPWR _0278_
+ sky130_fd_sc_hd__and2b_1
X_0754_ _0297_ _0335_ VGND VGND VPWR VPWR _0336_ sky130_fd_sc_hd__and2_1
XFILLER_0_3_279 VGND VGND VPWR VPWR sky130_fd_sc_hd__fill_1
XFILLER_0_9_37 VPWR VGND VPWR VGND sky130_ef_sc_hd__decap_12
X_0823_ cpu.bufreg.data\[1\] VGND VGND VPWR VPWR _0400_ sky130_fd_sc_hd__inv_2
X_1306_ net115 net116 _0572_ VGND VGND VPWR VPWR _0238_ sky130_fd_sc_hd__mux2_1
XFILLER_0_35_81 VGND VGND VPWR VPWR sky130_fd_sc_hd__fill_1
X_1168_ _0626_ VGND VGND VPWR VPWR _0114_ sky130_fd_sc_hd__clkbuf_1
X_1099_ _0575_ VGND VGND VPWR VPWR _0096_ sky130_fd_sc_hd__clkbuf_1
X_1237_ _0191_ VGND VGND VPWR VPWR _0140_ sky130_fd_sc_hd__clkbuf_1
XFILLER_0_34_149 VGND VGND VPWR VPWR sky130_fd_sc_hd__decap_6
XFILLER_0_34_105 VGND VGND VPWR VPWR sky130_fd_sc_hd__decap_4
XFILLER_0_19_146 VGND VGND VPWR VPWR sky130_fd_sc_hd__decap_4
XFILLER_0_30_300 VGND VGND VPWR VPWR sky130_fd_sc_hd__decap_8
X_1022_ _0268_ _0365_ _0473_ _0529_ VGND VGND VPWR VPWR _0530_ sky130_fd_sc_hd__a31o_1
XFILLER_0_21_61 VPWR VGND VPWR VGND sky130_ef_sc_hd__decap_12
X_0668_ _0254_ _0258_ _0261_ cpu.gen_csr.csr.o_new_irq VGND VGND VPWR VPWR _0264_
+ sky130_fd_sc_hd__a31o_1
X_0806_ cpu.decode.opcode\[2\] VGND VGND VPWR VPWR _0388_ sky130_fd_sc_hd__clkbuf_4
X_0737_ _0300_ _0318_ VGND VGND VPWR VPWR _0319_ sky130_fd_sc_hd__or2_1
XFILLER_0_47_241 VGND VGND VPWR VPWR sky130_fd_sc_hd__fill_1
XFILLER_0_39_219 VGND VGND VPWR VPWR sky130_fd_sc_hd__decap_4
XFILLER_0_1_60 VPWR VGND VPWR VGND sky130_ef_sc_hd__decap_12
XFILLER_0_30_185 VGND VGND VPWR VPWR sky130_fd_sc_hd__decap_8
XTAP_314 VGND VPWR sky130_fd_sc_hd__tapvpwrvgnd_1
XTAP_303 VGND VPWR sky130_fd_sc_hd__tapvpwrvgnd_1
XFILLER_0_6_27 VGND VGND VPWR VPWR sky130_fd_sc_hd__fill_1
XFILLER_0_21_163 VGND VGND VPWR VPWR sky130_fd_sc_hd__decap_4
XTAP_369 VGND VPWR sky130_fd_sc_hd__tapvpwrvgnd_1
XTAP_358 VGND VPWR sky130_fd_sc_hd__tapvpwrvgnd_1
XTAP_347 VGND VPWR sky130_fd_sc_hd__tapvpwrvgnd_1
XTAP_336 VGND VPWR sky130_fd_sc_hd__tapvpwrvgnd_1
XTAP_325 VGND VPWR sky130_fd_sc_hd__tapvpwrvgnd_1
XFILLER_0_8_113 VGND VGND VPWR VPWR sky130_fd_sc_hd__fill_1
XFILLER_0_8_124 VGND VGND VPWR VPWR sky130_fd_sc_hd__fill_1
X_1005_ net146 _0524_ _0525_ net147 VGND VGND VPWR VPWR _0052_ sky130_fd_sc_hd__a22o_1
XFILLER_0_44_266 VGND VGND VPWR VPWR sky130_fd_sc_hd__fill_1
XFILLER_0_12_141 VGND VGND VPWR VPWR sky130_fd_sc_hd__decap_6
XFILLER_0_35_233 VGND VGND VPWR VPWR sky130_fd_sc_hd__fill_2
Xoutput85 net85 VGND VGND VPWR VPWR o_dbus_adr[26] sky130_fd_sc_hd__clkbuf_4
Xoutput96 net96 VGND VGND VPWR VPWR o_dbus_adr[7] sky130_fd_sc_hd__clkbuf_4
Xoutput74 net74 VGND VGND VPWR VPWR o_dbus_adr[15] sky130_fd_sc_hd__clkbuf_4
XFILLER_0_41_225 VGND VGND VPWR VPWR sky130_fd_sc_hd__fill_2
XFILLER_0_5_138 VGND VGND VPWR VPWR sky130_fd_sc_hd__decap_3
XTAP_144 VGND VPWR sky130_fd_sc_hd__tapvpwrvgnd_1
XTAP_133 VGND VPWR sky130_fd_sc_hd__tapvpwrvgnd_1
XTAP_122 VGND VPWR sky130_fd_sc_hd__tapvpwrvgnd_1
XTAP_111 VGND VPWR sky130_fd_sc_hd__tapvpwrvgnd_1
XTAP_155 VGND VPWR sky130_fd_sc_hd__tapvpwrvgnd_1
XTAP_166 VGND VPWR sky130_fd_sc_hd__tapvpwrvgnd_1
X_1485_ clknet_4_10_0_clk _0147_ VGND VGND VPWR VPWR net129 sky130_fd_sc_hd__dfxtp_1
.ends
